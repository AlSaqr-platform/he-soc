{
    name: "control_register_config"
    clock_primary: "clk_i"
    reset_primary: "rst_ni"
    bus_interfaces: [
        { protocol: "reg_iface", direction: "device"}
    ]
    regwidth: 32,
    registers: [
      {
          name: CONTROL_CLUSTER
          desc: '''Cluster signal configuration.'''
          swaccess: "rw"
          fields: [
            {
                bits: "0"
                name: reset_n
                desc: '''Soft reset signal to the cluster'''
                swaccess: "rw"
                hwaccess: "hro"
                resval: "1"
            },
            {
                bits: "1"
                name: en_sa_boot
                desc: '''Enable for cluster's boot'''
                swaccess: "rw"
                hwaccess: "hro"
                resval: "0"
            },
            {
                bits: "2"
                name: fetch_en
                desc: '''Cluster fetch enable'''
                swaccess: "rw"
                hwaccess: "hro"
                resval: "0"
            },
          ]
      }
      {
           name: ENABLE_LLC_COUNTERS
           desc: "Enable LLC performance counters"
           swaccess: "rw"
           fields: [
              {
                 bits: "0"
                 name: llc_counter_en
                 desc: ''' LLC counters enable'''
                 swaccess: "rw"
                 hwaccess: "hro"
                 resval: "0"
              }
            ]
      }
      {
           name: LLC_READ_MISS_CACHE
           desc: "LLC read miss counter cached accesses"
           swaccess: "ro"
           hwaccess: "hwo"
           fields: [
              {
                 bits: "31:0"
                 name: llc_read_miss_cache
                 desc: ''' Number of miss read'''
              }
            ]
      }
      {
           name: LLC_READ_HIT_CACHE
           desc: "LLC read hit counter cached accesses"
           swaccess: "ro"
           hwaccess: "hwo"
           fields: [
              {
                 bits: "31:0"
                 name: llc_read_hit_cache
                 desc: ''' Number of hit read'''
              }
            ]
      }
      {
           name: LLC_WRITE_MISS_CACHE
           desc: "LLC write miss counter cached accesses"
           swaccess: "ro"
           hwaccess: "hwo"
           fields: [
              {
                 bits: "31:0"
                 name: llc_write_miss_cache
                 desc: ''' Number of miss write'''
              }
            ]
      }
      {
           name: LLC_WRITE_HIT_CACHE
           desc: "LLC write hit counter cached accesses"
           swaccess: "ro"
           hwaccess: "hwo"
           fields: [
              {
                 bits: "31:0"
                 name: llc_write_hit_cache
                 desc: ''' Number of miss write'''
              }
            ]
      }
  ]
}
