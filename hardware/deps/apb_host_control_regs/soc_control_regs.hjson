{
    name: "control_register_config"
    clock_primary: "clk_i"
    reset_primary: "rst_ni"
    bus_interfaces: [
        { protocol: "reg_iface", direction: "device"}
    ]
    regwidth: 32,
    registers: [
      {
          name: CONTROL_CLUSTER
          desc: '''Cluster signal configuration.'''
          swaccess: "rw"
          fields: [
            {
                bits: "0"
                name: reset_n
                desc: '''Soft reset signal to the cluster'''
                swaccess: "rw"
                hwaccess: "hro"
                resval: "1"
            },
            {
                bits: "1"
                name: en_sa_boot
                desc: '''Enable for cluster's boot'''
                swaccess: "rw"
                hwaccess: "hro"
                resval: "0"
            },
            {
                bits: "2"
                name: fetch_en
                desc: '''Cluster fetch enable'''
                swaccess: "rw"
                hwaccess: "hro"
                resval: "0"
            },
          ]
      }
      {
           name: ENABLE_LLC_COUNTERS
           desc: "Enable LLC performance counters"
           swaccess: "rw"
           fields: [
              {
                 bits: "0"
                 name: llc_counter_en
                 desc: ''' LLC counters enable'''
                 swaccess: "rw"
                 hwaccess: "hro"
                 resval: "0"
              }
            ]
      }
      {
           name: LLC_READ_MISS_CACHE
           desc: "LLC read miss counter cached accesses"
           swaccess: "ro"
           hwaccess: "hwo"
           fields: [
              {
                 bits: "31:0"
                 name: llc_read_miss_cache
                 desc: ''' Number of miss read'''
              }
            ]
      }
      {
           name: LLC_READ_HIT_CACHE
           desc: "LLC read hit counter cached accesses"
           swaccess: "ro"
           hwaccess: "hwo"
           fields: [
              {
                 bits: "31:0"
                 name: llc_read_hit_cache
                 desc: ''' Number of hit read'''
              }
            ]
      }
      {
           name: LLC_WRITE_MISS_CACHE
           desc: "LLC write miss counter cached accesses"
           swaccess: "ro"
           hwaccess: "hwo"
           fields: [
              {
                 bits: "31:0"
                 name: llc_write_miss_cache
                 desc: ''' Number of miss write'''
              }
            ]
      }
      {
           name: LLC_WRITE_HIT_CACHE
           desc: "LLC write hit counter cached accesses"
           swaccess: "ro"
           hwaccess: "hwo"
           fields: [
              {
                 bits: "31:0"
                 name: llc_write_hit_cache
                 desc: ''' Number of miss write'''
              }
            ]
      }
      {
           name: LLC_CACHE_ADDR_START
           desc: '''Start address of the LLC cache region'''
           swaccess: "rw"
           fields: [
              {
                 bits: "31:0"
                 name: llc_cache_addr_start
                 desc: '''Start address of the LLC cache region'''
                 swaccess: "rw"
                 hwaccess: "hro"
                 resval: "0x80000000"
              }
            ]
      }
      {
           name: LLC_CACHE_ADDR_END
           desc: '''End address of the LLC cache region'''
           swaccess: "rw"
           fields: [
              {
                 bits: "31:0"
                 name: llc_cache_addr_end
                 desc: '''End address of the LLC cache region'''
                 swaccess: "rw"
                 hwaccess: "hro"
                 resval: "0x80800000"
              }
            ]
      }
      {
           name: LLC_SPM_ADDR_START
           desc: '''Start address of the LLC SPM region'''
           swaccess: "rw"
           fields: [
              {
                 bits: "31:0"
                 name: llc_spm_addr_start
                 desc: '''Start address of the LLC SPM region'''
                 swaccess: "rw"
                 hwaccess: "hro"
                 resval: "0x70000000"
              }
            ]
      }
      {
           name: OT_CLK_SEL
           desc: '''Mux selector for Opentitan clock'''
           swaccess: "rw"
           fields: [
              {
                 bits: "1:0"
                 name: ot_clk_sel
                 desc: '''Mux selector for Opentitan clock'''
                 swaccess: "rw"
                 hwaccess: "hro"
                 resval: "0x1"
              }
            ]
      }
      {
           name: OT_CLK_DIV
           desc: '''Clock divider for Opentitan'''
           swaccess: "rw"
           hwaccess: "hro"
           hwqe: "true",
           resval: "0x1"
           fields: [
              {
                 bits: "31:0"
                 name: ot_clk_div
                 desc: '''Clock divider for Opentitan'''
              }
            ]
      }
      {
           name: OT_CLK_GATE_EN
           desc: '''Clock gate enable for Opentitan (active high)'''
           swaccess: "rw"
           fields: [
              {
                 bits: "0"
                 name: ot_clk_gate_en
                 desc: '''Clock gate enable for Opentitan (active high)'''
                 swaccess: "rw"
                 hwaccess: "hro"
                 resval: "0"
              }
            ]
      }
      { multireg:
          { name: LOGIC_LOCKING_KEY_0
            desc: '''First logic locking key'''
            count: "4"
            swaccess: "rw"
            hwaccess: "hro"
            cname: "LOGIC_LOCKING_KEY_0"
            fields: [
                { bits: "31:0"
                }
            ]
          }
      } 
      { multireg:
          { name: LOGIC_LOCKING_KEY_1
            desc: '''Second logic locking key'''
            count: "4"
            swaccess: "rw"
            hwaccess: "hro"
            cname: "LOGIC_LOCKING_KEY_1"
            fields: [
                { bits: "31:0"
                }
            ]
          }
      }
      { multireg:
          { name: LOGIC_LOCKING_KEY_2
            desc: '''Third logic locking key'''
            count: "4"
            swaccess: "rw"
            hwaccess: "hro"
            cname: "LOGIC_LOCKING_KEY_2"
            fields: [
                { bits: "31:0"
                }
            ]
          }
      } 
      { multireg:
          { name: LOGIC_LOCKING_KEY_3
            desc: '''Fourth logic locking key'''
            count: "4"
            swaccess: "rw"
            hwaccess: "hro"
            cname: "LOGIC_LOCKING_KEY_3"
            fields: [
                { bits: "31:0"
                }
            ]
          }
      }
  ]
}
