
{
    # File auto-generated by Padrick 0.1.0.post0.dev51+g806b078
    name: "alsaqr_periph_fpga_padframe_periphs_config"
    clock_primary: "clk_i"
    reset_primary: "rst_ni"
    bus_interfaces: [
        { protocol: "reg_iface", direction: "device"}
    ]
    regwidth: 32,
    registers: [
        {skipto: "0x0"},

      {
          name: PAD_GPIO_B_00_CFG
          desc: '''
            Pad signal configuration.
          '''
          swaccess: "rw"
          fields: [
            {
                bits: "0"
                name: chip2pad
                desc: '''
                     The signal that connects to the pads TX driver
                '''
                swaccess: "rw"
                hwaccess: "hro"
                resval: "0"
            },
            {
                bits: "2:1"
                name: drv
                desc: '''
                     Driving strength
                '''
                swaccess: "rw"
                hwaccess: "hro"
                resval: "0"
            },
            {
                bits: "3"
                name: oen
                desc: '''
                     Output enable signal, active low
                '''
                swaccess: "rw"
                hwaccess: "hro"
                resval: "1"
            },
            {
                bits: "4"
                name: puen
                desc: '''
                     Pull-Up enable signal, active low
                '''
                swaccess: "rw"
                hwaccess: "hro"
                resval: "1"
            },
            {
                bits: "5"
                name: slw
                desc: '''
                     
                '''
                swaccess: "rw"
                hwaccess: "hro"
                resval: "0"
            },
            {
                bits: "6"
                name: smt
                desc: '''
                     Schmit trigger enable
                '''
                swaccess: "rw"
                hwaccess: "hro"
                resval: "0"
            },
          ]
      }

       {
          name: PAD_GPIO_B_00_MUX_SEL
          desc: '''
              Pad signal port multiplex selection for pad pad_gpio_b_00. The programmed value defines which port
              is connected to the pad.
          '''
          swaccess: "rw"
          hwaccess: "hro"
          resval: 0
          fields: [
              {
                  bits: "1:0"
                  enum: [
                      { value: "0", name: "register", desc: "Connects the Pad to the internal configuration register."}
                      { value: "1", name: "port_gpio_b_gpio0", desc: "Connect port gpio0 from port group gpio_b to this pad." }
                      { value: "2", name: "port_spi0_spi_cs0", desc: "Connect port spi_cs0 from port group spi0 to this pad." }
                  ]
              }
          ]
      }

      {
          name: PAD_GPIO_B_01_CFG
          desc: '''
            Pad signal configuration.
          '''
          swaccess: "rw"
          fields: [
            {
                bits: "0"
                name: chip2pad
                desc: '''
                     The signal that connects to the pads TX driver
                '''
                swaccess: "rw"
                hwaccess: "hro"
                resval: "0"
            },
            {
                bits: "2:1"
                name: drv
                desc: '''
                     Driving strength
                '''
                swaccess: "rw"
                hwaccess: "hro"
                resval: "0"
            },
            {
                bits: "3"
                name: oen
                desc: '''
                     Output enable signal, active low
                '''
                swaccess: "rw"
                hwaccess: "hro"
                resval: "1"
            },
            {
                bits: "4"
                name: puen
                desc: '''
                     Pull-Up enable signal, active low
                '''
                swaccess: "rw"
                hwaccess: "hro"
                resval: "1"
            },
            {
                bits: "5"
                name: slw
                desc: '''
                     
                '''
                swaccess: "rw"
                hwaccess: "hro"
                resval: "0"
            },
            {
                bits: "6"
                name: smt
                desc: '''
                     Schmit trigger enable
                '''
                swaccess: "rw"
                hwaccess: "hro"
                resval: "0"
            },
          ]
      }

       {
          name: PAD_GPIO_B_01_MUX_SEL
          desc: '''
              Pad signal port multiplex selection for pad pad_gpio_b_01. The programmed value defines which port
              is connected to the pad.
          '''
          swaccess: "rw"
          hwaccess: "hro"
          resval: 0
          fields: [
              {
                  bits: "1:0"
                  enum: [
                      { value: "0", name: "register", desc: "Connects the Pad to the internal configuration register."}
                      { value: "1", name: "port_gpio_b_gpio1", desc: "Connect port gpio1 from port group gpio_b to this pad." }
                      { value: "2", name: "port_spi0_spi_sck", desc: "Connect port spi_sck from port group spi0 to this pad." }
                  ]
              }
          ]
      }

      {
          name: PAD_GPIO_B_02_CFG
          desc: '''
            Pad signal configuration.
          '''
          swaccess: "rw"
          fields: [
            {
                bits: "0"
                name: chip2pad
                desc: '''
                     The signal that connects to the pads TX driver
                '''
                swaccess: "rw"
                hwaccess: "hro"
                resval: "0"
            },
            {
                bits: "2:1"
                name: drv
                desc: '''
                     Driving strength
                '''
                swaccess: "rw"
                hwaccess: "hro"
                resval: "0"
            },
            {
                bits: "3"
                name: oen
                desc: '''
                     Output enable signal, active low
                '''
                swaccess: "rw"
                hwaccess: "hro"
                resval: "1"
            },
            {
                bits: "4"
                name: puen
                desc: '''
                     Pull-Up enable signal, active low
                '''
                swaccess: "rw"
                hwaccess: "hro"
                resval: "1"
            },
            {
                bits: "5"
                name: slw
                desc: '''
                     
                '''
                swaccess: "rw"
                hwaccess: "hro"
                resval: "0"
            },
            {
                bits: "6"
                name: smt
                desc: '''
                     Schmit trigger enable
                '''
                swaccess: "rw"
                hwaccess: "hro"
                resval: "0"
            },
          ]
      }

       {
          name: PAD_GPIO_B_02_MUX_SEL
          desc: '''
              Pad signal port multiplex selection for pad pad_gpio_b_02. The programmed value defines which port
              is connected to the pad.
          '''
          swaccess: "rw"
          hwaccess: "hro"
          resval: 0
          fields: [
              {
                  bits: "1:0"
                  enum: [
                      { value: "0", name: "register", desc: "Connects the Pad to the internal configuration register."}
                      { value: "1", name: "port_gpio_b_gpio2", desc: "Connect port gpio2 from port group gpio_b to this pad." }
                      { value: "2", name: "port_spi0_spi_miso", desc: "Connect port spi_miso from port group spi0 to this pad." }
                  ]
              }
          ]
      }

      {
          name: PAD_GPIO_B_03_CFG
          desc: '''
            Pad signal configuration.
          '''
          swaccess: "rw"
          fields: [
            {
                bits: "0"
                name: chip2pad
                desc: '''
                     The signal that connects to the pads TX driver
                '''
                swaccess: "rw"
                hwaccess: "hro"
                resval: "0"
            },
            {
                bits: "2:1"
                name: drv
                desc: '''
                     Driving strength
                '''
                swaccess: "rw"
                hwaccess: "hro"
                resval: "0"
            },
            {
                bits: "3"
                name: oen
                desc: '''
                     Output enable signal, active low
                '''
                swaccess: "rw"
                hwaccess: "hro"
                resval: "1"
            },
            {
                bits: "4"
                name: puen
                desc: '''
                     Pull-Up enable signal, active low
                '''
                swaccess: "rw"
                hwaccess: "hro"
                resval: "1"
            },
            {
                bits: "5"
                name: slw
                desc: '''
                     
                '''
                swaccess: "rw"
                hwaccess: "hro"
                resval: "0"
            },
            {
                bits: "6"
                name: smt
                desc: '''
                     Schmit trigger enable
                '''
                swaccess: "rw"
                hwaccess: "hro"
                resval: "0"
            },
          ]
      }

       {
          name: PAD_GPIO_B_03_MUX_SEL
          desc: '''
              Pad signal port multiplex selection for pad pad_gpio_b_03. The programmed value defines which port
              is connected to the pad.
          '''
          swaccess: "rw"
          hwaccess: "hro"
          resval: 0
          fields: [
              {
                  bits: "1:0"
                  enum: [
                      { value: "0", name: "register", desc: "Connects the Pad to the internal configuration register."}
                      { value: "1", name: "port_gpio_b_gpio3", desc: "Connect port gpio3 from port group gpio_b to this pad." }
                      { value: "2", name: "port_spi0_spi_mosi", desc: "Connect port spi_mosi from port group spi0 to this pad." }
                  ]
              }
          ]
      }

      {
          name: PAD_GPIO_B_04_CFG
          desc: '''
            Pad signal configuration.
          '''
          swaccess: "rw"
          fields: [
            {
                bits: "0"
                name: chip2pad
                desc: '''
                     The signal that connects to the pads TX driver
                '''
                swaccess: "rw"
                hwaccess: "hro"
                resval: "0"
            },
            {
                bits: "2:1"
                name: drv
                desc: '''
                     Driving strength
                '''
                swaccess: "rw"
                hwaccess: "hro"
                resval: "0"
            },
            {
                bits: "3"
                name: oen
                desc: '''
                     Output enable signal, active low
                '''
                swaccess: "rw"
                hwaccess: "hro"
                resval: "1"
            },
            {
                bits: "4"
                name: puen
                desc: '''
                     Pull-Up enable signal, active low
                '''
                swaccess: "rw"
                hwaccess: "hro"
                resval: "1"
            },
            {
                bits: "5"
                name: slw
                desc: '''
                     
                '''
                swaccess: "rw"
                hwaccess: "hro"
                resval: "0"
            },
            {
                bits: "6"
                name: smt
                desc: '''
                     Schmit trigger enable
                '''
                swaccess: "rw"
                hwaccess: "hro"
                resval: "0"
            },
          ]
      }

       {
          name: PAD_GPIO_B_04_MUX_SEL
          desc: '''
              Pad signal port multiplex selection for pad pad_gpio_b_04. The programmed value defines which port
              is connected to the pad.
          '''
          swaccess: "rw"
          hwaccess: "hro"
          resval: 0
          fields: [
              {
                  bits: "1:0"
                  enum: [
                      { value: "0", name: "register", desc: "Connects the Pad to the internal configuration register."}
                      { value: "1", name: "port_gpio_b_gpio4", desc: "Connect port gpio4 from port group gpio_b to this pad." }
                      { value: "2", name: "port_i2c0_i2c_scl", desc: "Connect port i2c_scl from port group i2c0 to this pad." }
                  ]
              }
          ]
      }

      {
          name: PAD_GPIO_B_05_CFG
          desc: '''
            Pad signal configuration.
          '''
          swaccess: "rw"
          fields: [
            {
                bits: "0"
                name: chip2pad
                desc: '''
                     The signal that connects to the pads TX driver
                '''
                swaccess: "rw"
                hwaccess: "hro"
                resval: "0"
            },
            {
                bits: "2:1"
                name: drv
                desc: '''
                     Driving strength
                '''
                swaccess: "rw"
                hwaccess: "hro"
                resval: "0"
            },
            {
                bits: "3"
                name: oen
                desc: '''
                     Output enable signal, active low
                '''
                swaccess: "rw"
                hwaccess: "hro"
                resval: "1"
            },
            {
                bits: "4"
                name: puen
                desc: '''
                     Pull-Up enable signal, active low
                '''
                swaccess: "rw"
                hwaccess: "hro"
                resval: "1"
            },
            {
                bits: "5"
                name: slw
                desc: '''
                     
                '''
                swaccess: "rw"
                hwaccess: "hro"
                resval: "0"
            },
            {
                bits: "6"
                name: smt
                desc: '''
                     Schmit trigger enable
                '''
                swaccess: "rw"
                hwaccess: "hro"
                resval: "0"
            },
          ]
      }

       {
          name: PAD_GPIO_B_05_MUX_SEL
          desc: '''
              Pad signal port multiplex selection for pad pad_gpio_b_05. The programmed value defines which port
              is connected to the pad.
          '''
          swaccess: "rw"
          hwaccess: "hro"
          resval: 0
          fields: [
              {
                  bits: "1:0"
                  enum: [
                      { value: "0", name: "register", desc: "Connects the Pad to the internal configuration register."}
                      { value: "1", name: "port_gpio_b_gpio5", desc: "Connect port gpio5 from port group gpio_b to this pad." }
                      { value: "2", name: "port_i2c0_i2c_sda", desc: "Connect port i2c_sda from port group i2c0 to this pad." }
                  ]
              }
          ]
      }

      {
          name: PAD_GPIO_B_06_CFG
          desc: '''
            Pad signal configuration.
          '''
          swaccess: "rw"
          fields: [
            {
                bits: "0"
                name: chip2pad
                desc: '''
                     The signal that connects to the pads TX driver
                '''
                swaccess: "rw"
                hwaccess: "hro"
                resval: "0"
            },
            {
                bits: "2:1"
                name: drv
                desc: '''
                     Driving strength
                '''
                swaccess: "rw"
                hwaccess: "hro"
                resval: "0"
            },
            {
                bits: "3"
                name: oen
                desc: '''
                     Output enable signal, active low
                '''
                swaccess: "rw"
                hwaccess: "hro"
                resval: "1"
            },
            {
                bits: "4"
                name: puen
                desc: '''
                     Pull-Up enable signal, active low
                '''
                swaccess: "rw"
                hwaccess: "hro"
                resval: "1"
            },
            {
                bits: "5"
                name: slw
                desc: '''
                     
                '''
                swaccess: "rw"
                hwaccess: "hro"
                resval: "0"
            },
            {
                bits: "6"
                name: smt
                desc: '''
                     Schmit trigger enable
                '''
                swaccess: "rw"
                hwaccess: "hro"
                resval: "0"
            },
          ]
      }

       {
          name: PAD_GPIO_B_06_MUX_SEL
          desc: '''
              Pad signal port multiplex selection for pad pad_gpio_b_06. The programmed value defines which port
              is connected to the pad.
          '''
          swaccess: "rw"
          hwaccess: "hro"
          resval: 0
          fields: [
              {
                  bits: "1:0"
                  enum: [
                      { value: "0", name: "register", desc: "Connects the Pad to the internal configuration register."}
                      { value: "1", name: "port_gpio_b_gpio6", desc: "Connect port gpio6 from port group gpio_b to this pad." }
                      { value: "2", name: "port_uart0_uart_tx", desc: "Connect port uart_tx from port group uart0 to this pad." }
                  ]
              }
          ]
      }

      {
          name: PAD_GPIO_B_07_CFG
          desc: '''
            Pad signal configuration.
          '''
          swaccess: "rw"
          fields: [
            {
                bits: "0"
                name: chip2pad
                desc: '''
                     The signal that connects to the pads TX driver
                '''
                swaccess: "rw"
                hwaccess: "hro"
                resval: "0"
            },
            {
                bits: "2:1"
                name: drv
                desc: '''
                     Driving strength
                '''
                swaccess: "rw"
                hwaccess: "hro"
                resval: "0"
            },
            {
                bits: "3"
                name: oen
                desc: '''
                     Output enable signal, active low
                '''
                swaccess: "rw"
                hwaccess: "hro"
                resval: "1"
            },
            {
                bits: "4"
                name: puen
                desc: '''
                     Pull-Up enable signal, active low
                '''
                swaccess: "rw"
                hwaccess: "hro"
                resval: "1"
            },
            {
                bits: "5"
                name: slw
                desc: '''
                     
                '''
                swaccess: "rw"
                hwaccess: "hro"
                resval: "0"
            },
            {
                bits: "6"
                name: smt
                desc: '''
                     Schmit trigger enable
                '''
                swaccess: "rw"
                hwaccess: "hro"
                resval: "0"
            },
          ]
      }

       {
          name: PAD_GPIO_B_07_MUX_SEL
          desc: '''
              Pad signal port multiplex selection for pad pad_gpio_b_07. The programmed value defines which port
              is connected to the pad.
          '''
          swaccess: "rw"
          hwaccess: "hro"
          resval: 0
          fields: [
              {
                  bits: "1:0"
                  enum: [
                      { value: "0", name: "register", desc: "Connects the Pad to the internal configuration register."}
                      { value: "1", name: "port_gpio_b_gpio7", desc: "Connect port gpio7 from port group gpio_b to this pad." }
                      { value: "2", name: "port_uart0_uart_rx", desc: "Connect port uart_rx from port group uart0 to this pad." }
                  ]
              }
          ]
      }

      {
          name: PAD_GPIO_B_08_CFG
          desc: '''
            Pad signal configuration.
          '''
          swaccess: "rw"
          fields: [
            {
                bits: "0"
                name: chip2pad
                desc: '''
                     The signal that connects to the pads TX driver
                '''
                swaccess: "rw"
                hwaccess: "hro"
                resval: "0"
            },
            {
                bits: "2:1"
                name: drv
                desc: '''
                     Driving strength
                '''
                swaccess: "rw"
                hwaccess: "hro"
                resval: "0"
            },
            {
                bits: "3"
                name: oen
                desc: '''
                     Output enable signal, active low
                '''
                swaccess: "rw"
                hwaccess: "hro"
                resval: "1"
            },
            {
                bits: "4"
                name: puen
                desc: '''
                     Pull-Up enable signal, active low
                '''
                swaccess: "rw"
                hwaccess: "hro"
                resval: "1"
            },
            {
                bits: "5"
                name: slw
                desc: '''
                     
                '''
                swaccess: "rw"
                hwaccess: "hro"
                resval: "0"
            },
            {
                bits: "6"
                name: smt
                desc: '''
                     Schmit trigger enable
                '''
                swaccess: "rw"
                hwaccess: "hro"
                resval: "0"
            },
          ]
      }

       {
          name: PAD_GPIO_B_08_MUX_SEL
          desc: '''
              Pad signal port multiplex selection for pad pad_gpio_b_08. The programmed value defines which port
              is connected to the pad.
          '''
          swaccess: "rw"
          hwaccess: "hro"
          resval: 0
          fields: [
              {
                  bits: "1:0"
                  enum: [
                      { value: "0", name: "register", desc: "Connects the Pad to the internal configuration register."}
                      { value: "1", name: "port_gpio_b_gpio8", desc: "Connect port gpio8 from port group gpio_b to this pad." }
                      { value: "2", name: "port_sdio0_sdio_data0", desc: "Connect port sdio_data0 from port group sdio0 to this pad." }
                  ]
              }
          ]
      }

      {
          name: PAD_GPIO_B_09_CFG
          desc: '''
            Pad signal configuration.
          '''
          swaccess: "rw"
          fields: [
            {
                bits: "0"
                name: chip2pad
                desc: '''
                     The signal that connects to the pads TX driver
                '''
                swaccess: "rw"
                hwaccess: "hro"
                resval: "0"
            },
            {
                bits: "2:1"
                name: drv
                desc: '''
                     Driving strength
                '''
                swaccess: "rw"
                hwaccess: "hro"
                resval: "0"
            },
            {
                bits: "3"
                name: oen
                desc: '''
                     Output enable signal, active low
                '''
                swaccess: "rw"
                hwaccess: "hro"
                resval: "1"
            },
            {
                bits: "4"
                name: puen
                desc: '''
                     Pull-Up enable signal, active low
                '''
                swaccess: "rw"
                hwaccess: "hro"
                resval: "1"
            },
            {
                bits: "5"
                name: slw
                desc: '''
                     
                '''
                swaccess: "rw"
                hwaccess: "hro"
                resval: "0"
            },
            {
                bits: "6"
                name: smt
                desc: '''
                     Schmit trigger enable
                '''
                swaccess: "rw"
                hwaccess: "hro"
                resval: "0"
            },
          ]
      }

       {
          name: PAD_GPIO_B_09_MUX_SEL
          desc: '''
              Pad signal port multiplex selection for pad pad_gpio_b_09. The programmed value defines which port
              is connected to the pad.
          '''
          swaccess: "rw"
          hwaccess: "hro"
          resval: 0
          fields: [
              {
                  bits: "1:0"
                  enum: [
                      { value: "0", name: "register", desc: "Connects the Pad to the internal configuration register."}
                      { value: "1", name: "port_gpio_b_gpio9", desc: "Connect port gpio9 from port group gpio_b to this pad." }
                      { value: "2", name: "port_sdio0_sdio_data1", desc: "Connect port sdio_data1 from port group sdio0 to this pad." }
                  ]
              }
          ]
      }

      {
          name: PAD_GPIO_B_10_CFG
          desc: '''
            Pad signal configuration.
          '''
          swaccess: "rw"
          fields: [
            {
                bits: "0"
                name: chip2pad
                desc: '''
                     The signal that connects to the pads TX driver
                '''
                swaccess: "rw"
                hwaccess: "hro"
                resval: "0"
            },
            {
                bits: "2:1"
                name: drv
                desc: '''
                     Driving strength
                '''
                swaccess: "rw"
                hwaccess: "hro"
                resval: "0"
            },
            {
                bits: "3"
                name: oen
                desc: '''
                     Output enable signal, active low
                '''
                swaccess: "rw"
                hwaccess: "hro"
                resval: "1"
            },
            {
                bits: "4"
                name: puen
                desc: '''
                     Pull-Up enable signal, active low
                '''
                swaccess: "rw"
                hwaccess: "hro"
                resval: "1"
            },
            {
                bits: "5"
                name: slw
                desc: '''
                     
                '''
                swaccess: "rw"
                hwaccess: "hro"
                resval: "0"
            },
            {
                bits: "6"
                name: smt
                desc: '''
                     Schmit trigger enable
                '''
                swaccess: "rw"
                hwaccess: "hro"
                resval: "0"
            },
          ]
      }

       {
          name: PAD_GPIO_B_10_MUX_SEL
          desc: '''
              Pad signal port multiplex selection for pad pad_gpio_b_10. The programmed value defines which port
              is connected to the pad.
          '''
          swaccess: "rw"
          hwaccess: "hro"
          resval: 0
          fields: [
              {
                  bits: "1:0"
                  enum: [
                      { value: "0", name: "register", desc: "Connects the Pad to the internal configuration register."}
                      { value: "1", name: "port_gpio_b_gpio10", desc: "Connect port gpio10 from port group gpio_b to this pad." }
                      { value: "2", name: "port_sdio0_sdio_data2", desc: "Connect port sdio_data2 from port group sdio0 to this pad." }
                  ]
              }
          ]
      }

      {
          name: PAD_GPIO_B_11_CFG
          desc: '''
            Pad signal configuration.
          '''
          swaccess: "rw"
          fields: [
            {
                bits: "0"
                name: chip2pad
                desc: '''
                     The signal that connects to the pads TX driver
                '''
                swaccess: "rw"
                hwaccess: "hro"
                resval: "0"
            },
            {
                bits: "2:1"
                name: drv
                desc: '''
                     Driving strength
                '''
                swaccess: "rw"
                hwaccess: "hro"
                resval: "0"
            },
            {
                bits: "3"
                name: oen
                desc: '''
                     Output enable signal, active low
                '''
                swaccess: "rw"
                hwaccess: "hro"
                resval: "1"
            },
            {
                bits: "4"
                name: puen
                desc: '''
                     Pull-Up enable signal, active low
                '''
                swaccess: "rw"
                hwaccess: "hro"
                resval: "1"
            },
            {
                bits: "5"
                name: slw
                desc: '''
                     
                '''
                swaccess: "rw"
                hwaccess: "hro"
                resval: "0"
            },
            {
                bits: "6"
                name: smt
                desc: '''
                     Schmit trigger enable
                '''
                swaccess: "rw"
                hwaccess: "hro"
                resval: "0"
            },
          ]
      }

       {
          name: PAD_GPIO_B_11_MUX_SEL
          desc: '''
              Pad signal port multiplex selection for pad pad_gpio_b_11. The programmed value defines which port
              is connected to the pad.
          '''
          swaccess: "rw"
          hwaccess: "hro"
          resval: 0
          fields: [
              {
                  bits: "1:0"
                  enum: [
                      { value: "0", name: "register", desc: "Connects the Pad to the internal configuration register."}
                      { value: "1", name: "port_gpio_b_gpio11", desc: "Connect port gpio11 from port group gpio_b to this pad." }
                      { value: "2", name: "port_sdio0_sdio_data3", desc: "Connect port sdio_data3 from port group sdio0 to this pad." }
                  ]
              }
          ]
      }

      {
          name: PAD_GPIO_B_12_CFG
          desc: '''
            Pad signal configuration.
          '''
          swaccess: "rw"
          fields: [
            {
                bits: "0"
                name: chip2pad
                desc: '''
                     The signal that connects to the pads TX driver
                '''
                swaccess: "rw"
                hwaccess: "hro"
                resval: "0"
            },
            {
                bits: "2:1"
                name: drv
                desc: '''
                     Driving strength
                '''
                swaccess: "rw"
                hwaccess: "hro"
                resval: "0"
            },
            {
                bits: "3"
                name: oen
                desc: '''
                     Output enable signal, active low
                '''
                swaccess: "rw"
                hwaccess: "hro"
                resval: "1"
            },
            {
                bits: "4"
                name: puen
                desc: '''
                     Pull-Up enable signal, active low
                '''
                swaccess: "rw"
                hwaccess: "hro"
                resval: "1"
            },
            {
                bits: "5"
                name: slw
                desc: '''
                     
                '''
                swaccess: "rw"
                hwaccess: "hro"
                resval: "0"
            },
            {
                bits: "6"
                name: smt
                desc: '''
                     Schmit trigger enable
                '''
                swaccess: "rw"
                hwaccess: "hro"
                resval: "0"
            },
          ]
      }

       {
          name: PAD_GPIO_B_12_MUX_SEL
          desc: '''
              Pad signal port multiplex selection for pad pad_gpio_b_12. The programmed value defines which port
              is connected to the pad.
          '''
          swaccess: "rw"
          hwaccess: "hro"
          resval: 0
          fields: [
              {
                  bits: "1:0"
                  enum: [
                      { value: "0", name: "register", desc: "Connects the Pad to the internal configuration register."}
                      { value: "1", name: "port_gpio_b_gpio12", desc: "Connect port gpio12 from port group gpio_b to this pad." }
                      { value: "2", name: "port_sdio0_sdio_clk", desc: "Connect port sdio_clk from port group sdio0 to this pad." }
                  ]
              }
          ]
      }

      {
          name: PAD_GPIO_B_13_CFG
          desc: '''
            Pad signal configuration.
          '''
          swaccess: "rw"
          fields: [
            {
                bits: "0"
                name: chip2pad
                desc: '''
                     The signal that connects to the pads TX driver
                '''
                swaccess: "rw"
                hwaccess: "hro"
                resval: "0"
            },
            {
                bits: "2:1"
                name: drv
                desc: '''
                     Driving strength
                '''
                swaccess: "rw"
                hwaccess: "hro"
                resval: "0"
            },
            {
                bits: "3"
                name: oen
                desc: '''
                     Output enable signal, active low
                '''
                swaccess: "rw"
                hwaccess: "hro"
                resval: "1"
            },
            {
                bits: "4"
                name: puen
                desc: '''
                     Pull-Up enable signal, active low
                '''
                swaccess: "rw"
                hwaccess: "hro"
                resval: "1"
            },
            {
                bits: "5"
                name: slw
                desc: '''
                     
                '''
                swaccess: "rw"
                hwaccess: "hro"
                resval: "0"
            },
            {
                bits: "6"
                name: smt
                desc: '''
                     Schmit trigger enable
                '''
                swaccess: "rw"
                hwaccess: "hro"
                resval: "0"
            },
          ]
      }

       {
          name: PAD_GPIO_B_13_MUX_SEL
          desc: '''
              Pad signal port multiplex selection for pad pad_gpio_b_13. The programmed value defines which port
              is connected to the pad.
          '''
          swaccess: "rw"
          hwaccess: "hro"
          resval: 0
          fields: [
              {
                  bits: "1:0"
                  enum: [
                      { value: "0", name: "register", desc: "Connects the Pad to the internal configuration register."}
                      { value: "1", name: "port_gpio_b_gpio13", desc: "Connect port gpio13 from port group gpio_b to this pad." }
                      { value: "2", name: "port_sdio0_sdio_cmd", desc: "Connect port sdio_cmd from port group sdio0 to this pad." }
                  ]
              }
          ]
      }

      {
          name: PAD_GPIO_B_14_CFG
          desc: '''
            Pad signal configuration.
          '''
          swaccess: "rw"
          fields: [
            {
                bits: "0"
                name: chip2pad
                desc: '''
                     The signal that connects to the pads TX driver
                '''
                swaccess: "rw"
                hwaccess: "hro"
                resval: "0"
            },
            {
                bits: "2:1"
                name: drv
                desc: '''
                     Driving strength
                '''
                swaccess: "rw"
                hwaccess: "hro"
                resval: "0"
            },
            {
                bits: "3"
                name: oen
                desc: '''
                     Output enable signal, active low
                '''
                swaccess: "rw"
                hwaccess: "hro"
                resval: "1"
            },
            {
                bits: "4"
                name: puen
                desc: '''
                     Pull-Up enable signal, active low
                '''
                swaccess: "rw"
                hwaccess: "hro"
                resval: "1"
            },
            {
                bits: "5"
                name: slw
                desc: '''
                     
                '''
                swaccess: "rw"
                hwaccess: "hro"
                resval: "0"
            },
            {
                bits: "6"
                name: smt
                desc: '''
                     Schmit trigger enable
                '''
                swaccess: "rw"
                hwaccess: "hro"
                resval: "0"
            },
          ]
      }

       {
          name: PAD_GPIO_B_14_MUX_SEL
          desc: '''
              Pad signal port multiplex selection for pad pad_gpio_b_14. The programmed value defines which port
              is connected to the pad.
          '''
          swaccess: "rw"
          hwaccess: "hro"
          resval: 0
          fields: [
              {
                  bits: "1:0"
                  enum: [
                      { value: "0", name: "register", desc: "Connects the Pad to the internal configuration register."}
                      { value: "1", name: "port_gpio_b_gpio14", desc: "Connect port gpio14 from port group gpio_b to this pad." }
                      { value: "2", name: "port_qspi_ot_qspi_sck", desc: "Connect port qspi_sck from port group qspi_ot to this pad." }
                  ]
              }
          ]
      }

      {
          name: PAD_GPIO_B_15_CFG
          desc: '''
            Pad signal configuration.
          '''
          swaccess: "rw"
          fields: [
            {
                bits: "0"
                name: chip2pad
                desc: '''
                     The signal that connects to the pads TX driver
                '''
                swaccess: "rw"
                hwaccess: "hro"
                resval: "0"
            },
            {
                bits: "2:1"
                name: drv
                desc: '''
                     Driving strength
                '''
                swaccess: "rw"
                hwaccess: "hro"
                resval: "0"
            },
            {
                bits: "3"
                name: oen
                desc: '''
                     Output enable signal, active low
                '''
                swaccess: "rw"
                hwaccess: "hro"
                resval: "1"
            },
            {
                bits: "4"
                name: puen
                desc: '''
                     Pull-Up enable signal, active low
                '''
                swaccess: "rw"
                hwaccess: "hro"
                resval: "1"
            },
            {
                bits: "5"
                name: slw
                desc: '''
                     
                '''
                swaccess: "rw"
                hwaccess: "hro"
                resval: "0"
            },
            {
                bits: "6"
                name: smt
                desc: '''
                     Schmit trigger enable
                '''
                swaccess: "rw"
                hwaccess: "hro"
                resval: "0"
            },
          ]
      }

       {
          name: PAD_GPIO_B_15_MUX_SEL
          desc: '''
              Pad signal port multiplex selection for pad pad_gpio_b_15. The programmed value defines which port
              is connected to the pad.
          '''
          swaccess: "rw"
          hwaccess: "hro"
          resval: 0
          fields: [
              {
                  bits: "1:0"
                  enum: [
                      { value: "0", name: "register", desc: "Connects the Pad to the internal configuration register."}
                      { value: "1", name: "port_gpio_b_gpio15", desc: "Connect port gpio15 from port group gpio_b to this pad." }
                      { value: "2", name: "port_qspi_ot_qspi_csn", desc: "Connect port qspi_csn from port group qspi_ot to this pad." }
                  ]
              }
          ]
      }

      {
          name: PAD_GPIO_B_16_CFG
          desc: '''
            Pad signal configuration.
          '''
          swaccess: "rw"
          fields: [
            {
                bits: "0"
                name: chip2pad
                desc: '''
                     The signal that connects to the pads TX driver
                '''
                swaccess: "rw"
                hwaccess: "hro"
                resval: "0"
            },
            {
                bits: "2:1"
                name: drv
                desc: '''
                     Driving strength
                '''
                swaccess: "rw"
                hwaccess: "hro"
                resval: "0"
            },
            {
                bits: "3"
                name: oen
                desc: '''
                     Output enable signal, active low
                '''
                swaccess: "rw"
                hwaccess: "hro"
                resval: "1"
            },
            {
                bits: "4"
                name: puen
                desc: '''
                     Pull-Up enable signal, active low
                '''
                swaccess: "rw"
                hwaccess: "hro"
                resval: "1"
            },
            {
                bits: "5"
                name: slw
                desc: '''
                     
                '''
                swaccess: "rw"
                hwaccess: "hro"
                resval: "0"
            },
            {
                bits: "6"
                name: smt
                desc: '''
                     Schmit trigger enable
                '''
                swaccess: "rw"
                hwaccess: "hro"
                resval: "0"
            },
          ]
      }

       {
          name: PAD_GPIO_B_16_MUX_SEL
          desc: '''
              Pad signal port multiplex selection for pad pad_gpio_b_16. The programmed value defines which port
              is connected to the pad.
          '''
          swaccess: "rw"
          hwaccess: "hro"
          resval: 0
          fields: [
              {
                  bits: "1:0"
                  enum: [
                      { value: "0", name: "register", desc: "Connects the Pad to the internal configuration register."}
                      { value: "1", name: "port_gpio_b_gpio16", desc: "Connect port gpio16 from port group gpio_b to this pad." }
                      { value: "2", name: "port_qspi_ot_qspi_sd0", desc: "Connect port qspi_sd0 from port group qspi_ot to this pad." }
                  ]
              }
          ]
      }

      {
          name: PAD_GPIO_B_17_CFG
          desc: '''
            Pad signal configuration.
          '''
          swaccess: "rw"
          fields: [
            {
                bits: "0"
                name: chip2pad
                desc: '''
                     The signal that connects to the pads TX driver
                '''
                swaccess: "rw"
                hwaccess: "hro"
                resval: "0"
            },
            {
                bits: "2:1"
                name: drv
                desc: '''
                     Driving strength
                '''
                swaccess: "rw"
                hwaccess: "hro"
                resval: "0"
            },
            {
                bits: "3"
                name: oen
                desc: '''
                     Output enable signal, active low
                '''
                swaccess: "rw"
                hwaccess: "hro"
                resval: "1"
            },
            {
                bits: "4"
                name: puen
                desc: '''
                     Pull-Up enable signal, active low
                '''
                swaccess: "rw"
                hwaccess: "hro"
                resval: "1"
            },
            {
                bits: "5"
                name: slw
                desc: '''
                     
                '''
                swaccess: "rw"
                hwaccess: "hro"
                resval: "0"
            },
            {
                bits: "6"
                name: smt
                desc: '''
                     Schmit trigger enable
                '''
                swaccess: "rw"
                hwaccess: "hro"
                resval: "0"
            },
          ]
      }

       {
          name: PAD_GPIO_B_17_MUX_SEL
          desc: '''
              Pad signal port multiplex selection for pad pad_gpio_b_17. The programmed value defines which port
              is connected to the pad.
          '''
          swaccess: "rw"
          hwaccess: "hro"
          resval: 0
          fields: [
              {
                  bits: "1:0"
                  enum: [
                      { value: "0", name: "register", desc: "Connects the Pad to the internal configuration register."}
                      { value: "1", name: "port_gpio_b_gpio17", desc: "Connect port gpio17 from port group gpio_b to this pad." }
                      { value: "2", name: "port_qspi_ot_qspi_sd1", desc: "Connect port qspi_sd1 from port group qspi_ot to this pad." }
                  ]
              }
          ]
      }

      {
          name: PAD_GPIO_B_18_CFG
          desc: '''
            Pad signal configuration.
          '''
          swaccess: "rw"
          fields: [
            {
                bits: "0"
                name: chip2pad
                desc: '''
                     The signal that connects to the pads TX driver
                '''
                swaccess: "rw"
                hwaccess: "hro"
                resval: "0"
            },
            {
                bits: "2:1"
                name: drv
                desc: '''
                     Driving strength
                '''
                swaccess: "rw"
                hwaccess: "hro"
                resval: "0"
            },
            {
                bits: "3"
                name: oen
                desc: '''
                     Output enable signal, active low
                '''
                swaccess: "rw"
                hwaccess: "hro"
                resval: "1"
            },
            {
                bits: "4"
                name: puen
                desc: '''
                     Pull-Up enable signal, active low
                '''
                swaccess: "rw"
                hwaccess: "hro"
                resval: "1"
            },
            {
                bits: "5"
                name: slw
                desc: '''
                     
                '''
                swaccess: "rw"
                hwaccess: "hro"
                resval: "0"
            },
            {
                bits: "6"
                name: smt
                desc: '''
                     Schmit trigger enable
                '''
                swaccess: "rw"
                hwaccess: "hro"
                resval: "0"
            },
          ]
      }

       {
          name: PAD_GPIO_B_18_MUX_SEL
          desc: '''
              Pad signal port multiplex selection for pad pad_gpio_b_18. The programmed value defines which port
              is connected to the pad.
          '''
          swaccess: "rw"
          hwaccess: "hro"
          resval: 0
          fields: [
              {
                  bits: "1:0"
                  enum: [
                      { value: "0", name: "register", desc: "Connects the Pad to the internal configuration register."}
                      { value: "1", name: "port_gpio_b_gpio18", desc: "Connect port gpio18 from port group gpio_b to this pad." }
                      { value: "2", name: "port_qspi_ot_qspi_sd2", desc: "Connect port qspi_sd2 from port group qspi_ot to this pad." }
                  ]
              }
          ]
      }

      {
          name: PAD_GPIO_B_19_CFG
          desc: '''
            Pad signal configuration.
          '''
          swaccess: "rw"
          fields: [
            {
                bits: "0"
                name: chip2pad
                desc: '''
                     The signal that connects to the pads TX driver
                '''
                swaccess: "rw"
                hwaccess: "hro"
                resval: "0"
            },
            {
                bits: "2:1"
                name: drv
                desc: '''
                     Driving strength
                '''
                swaccess: "rw"
                hwaccess: "hro"
                resval: "0"
            },
            {
                bits: "3"
                name: oen
                desc: '''
                     Output enable signal, active low
                '''
                swaccess: "rw"
                hwaccess: "hro"
                resval: "1"
            },
            {
                bits: "4"
                name: puen
                desc: '''
                     Pull-Up enable signal, active low
                '''
                swaccess: "rw"
                hwaccess: "hro"
                resval: "1"
            },
            {
                bits: "5"
                name: slw
                desc: '''
                     
                '''
                swaccess: "rw"
                hwaccess: "hro"
                resval: "0"
            },
            {
                bits: "6"
                name: smt
                desc: '''
                     Schmit trigger enable
                '''
                swaccess: "rw"
                hwaccess: "hro"
                resval: "0"
            },
          ]
      }

       {
          name: PAD_GPIO_B_19_MUX_SEL
          desc: '''
              Pad signal port multiplex selection for pad pad_gpio_b_19. The programmed value defines which port
              is connected to the pad.
          '''
          swaccess: "rw"
          hwaccess: "hro"
          resval: 0
          fields: [
              {
                  bits: "1:0"
                  enum: [
                      { value: "0", name: "register", desc: "Connects the Pad to the internal configuration register."}
                      { value: "1", name: "port_gpio_b_gpio19", desc: "Connect port gpio19 from port group gpio_b to this pad." }
                      { value: "2", name: "port_qspi_ot_qspi_sd3", desc: "Connect port qspi_sd3 from port group qspi_ot to this pad." }
                  ]
              }
          ]
      }

      {
          name: PAD_GPIO_B_20_CFG
          desc: '''
            Pad signal configuration.
          '''
          swaccess: "rw"
          fields: [
            {
                bits: "0"
                name: chip2pad
                desc: '''
                     The signal that connects to the pads TX driver
                '''
                swaccess: "rw"
                hwaccess: "hro"
                resval: "0"
            },
            {
                bits: "2:1"
                name: drv
                desc: '''
                     Driving strength
                '''
                swaccess: "rw"
                hwaccess: "hro"
                resval: "0"
            },
            {
                bits: "3"
                name: oen
                desc: '''
                     Output enable signal, active low
                '''
                swaccess: "rw"
                hwaccess: "hro"
                resval: "1"
            },
            {
                bits: "4"
                name: puen
                desc: '''
                     Pull-Up enable signal, active low
                '''
                swaccess: "rw"
                hwaccess: "hro"
                resval: "1"
            },
            {
                bits: "5"
                name: slw
                desc: '''
                     
                '''
                swaccess: "rw"
                hwaccess: "hro"
                resval: "0"
            },
            {
                bits: "6"
                name: smt
                desc: '''
                     Schmit trigger enable
                '''
                swaccess: "rw"
                hwaccess: "hro"
                resval: "0"
            },
          ]
      }

       {
          name: PAD_GPIO_B_20_MUX_SEL
          desc: '''
              Pad signal port multiplex selection for pad pad_gpio_b_20. The programmed value defines which port
              is connected to the pad.
          '''
          swaccess: "rw"
          hwaccess: "hro"
          resval: 0
          fields: [
              {
                  bits: "1:0"
                  enum: [
                      { value: "0", name: "register", desc: "Connects the Pad to the internal configuration register."}
                      { value: "1", name: "port_gpio_b_gpio20", desc: "Connect port gpio20 from port group gpio_b to this pad." }
                      { value: "2", name: "port_qspi_qspi_sck", desc: "Connect port qspi_sck from port group qspi to this pad." }
                  ]
              }
          ]
      }

      {
          name: PAD_GPIO_B_21_CFG
          desc: '''
            Pad signal configuration.
          '''
          swaccess: "rw"
          fields: [
            {
                bits: "0"
                name: chip2pad
                desc: '''
                     The signal that connects to the pads TX driver
                '''
                swaccess: "rw"
                hwaccess: "hro"
                resval: "0"
            },
            {
                bits: "2:1"
                name: drv
                desc: '''
                     Driving strength
                '''
                swaccess: "rw"
                hwaccess: "hro"
                resval: "0"
            },
            {
                bits: "3"
                name: oen
                desc: '''
                     Output enable signal, active low
                '''
                swaccess: "rw"
                hwaccess: "hro"
                resval: "1"
            },
            {
                bits: "4"
                name: puen
                desc: '''
                     Pull-Up enable signal, active low
                '''
                swaccess: "rw"
                hwaccess: "hro"
                resval: "1"
            },
            {
                bits: "5"
                name: slw
                desc: '''
                     
                '''
                swaccess: "rw"
                hwaccess: "hro"
                resval: "0"
            },
            {
                bits: "6"
                name: smt
                desc: '''
                     Schmit trigger enable
                '''
                swaccess: "rw"
                hwaccess: "hro"
                resval: "0"
            },
          ]
      }

       {
          name: PAD_GPIO_B_21_MUX_SEL
          desc: '''
              Pad signal port multiplex selection for pad pad_gpio_b_21. The programmed value defines which port
              is connected to the pad.
          '''
          swaccess: "rw"
          hwaccess: "hro"
          resval: 0
          fields: [
              {
                  bits: "1:0"
                  enum: [
                      { value: "0", name: "register", desc: "Connects the Pad to the internal configuration register."}
                      { value: "1", name: "port_gpio_b_gpio21", desc: "Connect port gpio21 from port group gpio_b to this pad." }
                      { value: "2", name: "port_qspi_qspi_csn", desc: "Connect port qspi_csn from port group qspi to this pad." }
                  ]
              }
          ]
      }

      {
          name: PAD_GPIO_B_22_CFG
          desc: '''
            Pad signal configuration.
          '''
          swaccess: "rw"
          fields: [
            {
                bits: "0"
                name: chip2pad
                desc: '''
                     The signal that connects to the pads TX driver
                '''
                swaccess: "rw"
                hwaccess: "hro"
                resval: "0"
            },
            {
                bits: "2:1"
                name: drv
                desc: '''
                     Driving strength
                '''
                swaccess: "rw"
                hwaccess: "hro"
                resval: "0"
            },
            {
                bits: "3"
                name: oen
                desc: '''
                     Output enable signal, active low
                '''
                swaccess: "rw"
                hwaccess: "hro"
                resval: "1"
            },
            {
                bits: "4"
                name: puen
                desc: '''
                     Pull-Up enable signal, active low
                '''
                swaccess: "rw"
                hwaccess: "hro"
                resval: "1"
            },
            {
                bits: "5"
                name: slw
                desc: '''
                     
                '''
                swaccess: "rw"
                hwaccess: "hro"
                resval: "0"
            },
            {
                bits: "6"
                name: smt
                desc: '''
                     Schmit trigger enable
                '''
                swaccess: "rw"
                hwaccess: "hro"
                resval: "0"
            },
          ]
      }

       {
          name: PAD_GPIO_B_22_MUX_SEL
          desc: '''
              Pad signal port multiplex selection for pad pad_gpio_b_22. The programmed value defines which port
              is connected to the pad.
          '''
          swaccess: "rw"
          hwaccess: "hro"
          resval: 0
          fields: [
              {
                  bits: "1:0"
                  enum: [
                      { value: "0", name: "register", desc: "Connects the Pad to the internal configuration register."}
                      { value: "1", name: "port_gpio_b_gpio22", desc: "Connect port gpio22 from port group gpio_b to this pad." }
                      { value: "2", name: "port_qspi_qspi_sd0", desc: "Connect port qspi_sd0 from port group qspi to this pad." }
                  ]
              }
          ]
      }

      {
          name: PAD_GPIO_B_23_CFG
          desc: '''
            Pad signal configuration.
          '''
          swaccess: "rw"
          fields: [
            {
                bits: "0"
                name: chip2pad
                desc: '''
                     The signal that connects to the pads TX driver
                '''
                swaccess: "rw"
                hwaccess: "hro"
                resval: "0"
            },
            {
                bits: "2:1"
                name: drv
                desc: '''
                     Driving strength
                '''
                swaccess: "rw"
                hwaccess: "hro"
                resval: "0"
            },
            {
                bits: "3"
                name: oen
                desc: '''
                     Output enable signal, active low
                '''
                swaccess: "rw"
                hwaccess: "hro"
                resval: "1"
            },
            {
                bits: "4"
                name: puen
                desc: '''
                     Pull-Up enable signal, active low
                '''
                swaccess: "rw"
                hwaccess: "hro"
                resval: "1"
            },
            {
                bits: "5"
                name: slw
                desc: '''
                     
                '''
                swaccess: "rw"
                hwaccess: "hro"
                resval: "0"
            },
            {
                bits: "6"
                name: smt
                desc: '''
                     Schmit trigger enable
                '''
                swaccess: "rw"
                hwaccess: "hro"
                resval: "0"
            },
          ]
      }

       {
          name: PAD_GPIO_B_23_MUX_SEL
          desc: '''
              Pad signal port multiplex selection for pad pad_gpio_b_23. The programmed value defines which port
              is connected to the pad.
          '''
          swaccess: "rw"
          hwaccess: "hro"
          resval: 0
          fields: [
              {
                  bits: "1:0"
                  enum: [
                      { value: "0", name: "register", desc: "Connects the Pad to the internal configuration register."}
                      { value: "1", name: "port_gpio_b_gpio23", desc: "Connect port gpio23 from port group gpio_b to this pad." }
                      { value: "2", name: "port_qspi_qspi_sd1", desc: "Connect port qspi_sd1 from port group qspi to this pad." }
                  ]
              }
          ]
      }

      {
          name: PAD_GPIO_B_24_CFG
          desc: '''
            Pad signal configuration.
          '''
          swaccess: "rw"
          fields: [
            {
                bits: "0"
                name: chip2pad
                desc: '''
                     The signal that connects to the pads TX driver
                '''
                swaccess: "rw"
                hwaccess: "hro"
                resval: "0"
            },
            {
                bits: "2:1"
                name: drv
                desc: '''
                     Driving strength
                '''
                swaccess: "rw"
                hwaccess: "hro"
                resval: "0"
            },
            {
                bits: "3"
                name: oen
                desc: '''
                     Output enable signal, active low
                '''
                swaccess: "rw"
                hwaccess: "hro"
                resval: "1"
            },
            {
                bits: "4"
                name: puen
                desc: '''
                     Pull-Up enable signal, active low
                '''
                swaccess: "rw"
                hwaccess: "hro"
                resval: "1"
            },
            {
                bits: "5"
                name: slw
                desc: '''
                     
                '''
                swaccess: "rw"
                hwaccess: "hro"
                resval: "0"
            },
            {
                bits: "6"
                name: smt
                desc: '''
                     Schmit trigger enable
                '''
                swaccess: "rw"
                hwaccess: "hro"
                resval: "0"
            },
          ]
      }

       {
          name: PAD_GPIO_B_24_MUX_SEL
          desc: '''
              Pad signal port multiplex selection for pad pad_gpio_b_24. The programmed value defines which port
              is connected to the pad.
          '''
          swaccess: "rw"
          hwaccess: "hro"
          resval: 0
          fields: [
              {
                  bits: "1:0"
                  enum: [
                      { value: "0", name: "register", desc: "Connects the Pad to the internal configuration register."}
                      { value: "1", name: "port_gpio_b_gpio24", desc: "Connect port gpio24 from port group gpio_b to this pad." }
                      { value: "2", name: "port_qspi_qspi_sd2", desc: "Connect port qspi_sd2 from port group qspi to this pad." }
                  ]
              }
          ]
      }

      {
          name: PAD_GPIO_B_25_CFG
          desc: '''
            Pad signal configuration.
          '''
          swaccess: "rw"
          fields: [
            {
                bits: "0"
                name: chip2pad
                desc: '''
                     The signal that connects to the pads TX driver
                '''
                swaccess: "rw"
                hwaccess: "hro"
                resval: "0"
            },
            {
                bits: "2:1"
                name: drv
                desc: '''
                     Driving strength
                '''
                swaccess: "rw"
                hwaccess: "hro"
                resval: "0"
            },
            {
                bits: "3"
                name: oen
                desc: '''
                     Output enable signal, active low
                '''
                swaccess: "rw"
                hwaccess: "hro"
                resval: "1"
            },
            {
                bits: "4"
                name: puen
                desc: '''
                     Pull-Up enable signal, active low
                '''
                swaccess: "rw"
                hwaccess: "hro"
                resval: "1"
            },
            {
                bits: "5"
                name: slw
                desc: '''
                     
                '''
                swaccess: "rw"
                hwaccess: "hro"
                resval: "0"
            },
            {
                bits: "6"
                name: smt
                desc: '''
                     Schmit trigger enable
                '''
                swaccess: "rw"
                hwaccess: "hro"
                resval: "0"
            },
          ]
      }

       {
          name: PAD_GPIO_B_25_MUX_SEL
          desc: '''
              Pad signal port multiplex selection for pad pad_gpio_b_25. The programmed value defines which port
              is connected to the pad.
          '''
          swaccess: "rw"
          hwaccess: "hro"
          resval: 0
          fields: [
              {
                  bits: "1:0"
                  enum: [
                      { value: "0", name: "register", desc: "Connects the Pad to the internal configuration register."}
                      { value: "1", name: "port_gpio_b_gpio25", desc: "Connect port gpio25 from port group gpio_b to this pad." }
                      { value: "2", name: "port_qspi_qspi_sd3", desc: "Connect port qspi_sd3 from port group qspi to this pad." }
                  ]
              }
          ]
      }

    ]
}
