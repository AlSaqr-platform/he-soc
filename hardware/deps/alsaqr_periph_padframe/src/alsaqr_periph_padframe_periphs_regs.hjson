
{
    # File auto-generated by Padrick 0.1.0.post0.dev51+g806b078.dirty
    name: "alsaqr_periph_padframe_periphs_config"
    clock_primary: "clk_i"
    reset_primary: "rst_ni"
    bus_interfaces: [
        { protocol: "reg_iface", direction: "device"}
    ]
    regwidth: 32,
    registers: [
        {skipto: "0x0"},

      {
          name: A_00_CFG
          desc: '''
            Pad signal configuration.
          '''
          swaccess: "rw"
          fields: [
            {
                bits: "0"
                name: chip2pad
                desc: '''
                     The signal that connects to the pads TX driver
                '''
                swaccess: "rw"
                hwaccess: "hro"
                resval: "0"
            },
            {
                bits: "2:1"
                name: drv
                desc: '''
                     Driving strength
                '''
                swaccess: "rw"
                hwaccess: "hro"
                resval: "0"
            },
            {
                bits: "3"
                name: oen
                desc: '''
                     Output enable signal, active low
                '''
                swaccess: "rw"
                hwaccess: "hro"
                resval: "1"
            },
            {
                bits: "4"
                name: puen
                desc: '''
                     Pull-Up enable signal, active low
                '''
                swaccess: "rw"
                hwaccess: "hro"
                resval: "1"
            },
            {
                bits: "5"
                name: slw
                desc: '''
                     
                '''
                swaccess: "rw"
                hwaccess: "hro"
                resval: "0"
            },
            {
                bits: "6"
                name: smt
                desc: '''
                     Schmit trigger enable
                '''
                swaccess: "rw"
                hwaccess: "hro"
                resval: "0"
            },
          ]
      }

       {
          name: A_00_MUX_SEL
          desc: '''
              Pad signal port multiplex selection for pad a_00. The programmed value defines which port
              is connected to the pad.
          '''
          swaccess: "rw"
          hwaccess: "hro"
          resval: 0
          fields: [
              {
                  bits: "0:0"
                  enum: [
                      { value: "0", name: "register", desc: "Connects the Pad to the internal configuration register."}
                      { value: "1", name: "port_i2c0_i2c_scl", desc: "Connect port i2c_scl from port group i2c0 to this pad." }
                  ]
              }
          ]
      }

      {
          name: A_01_CFG
          desc: '''
            Pad signal configuration.
          '''
          swaccess: "rw"
          fields: [
            {
                bits: "0"
                name: chip2pad
                desc: '''
                     The signal that connects to the pads TX driver
                '''
                swaccess: "rw"
                hwaccess: "hro"
                resval: "0"
            },
            {
                bits: "2:1"
                name: drv
                desc: '''
                     Driving strength
                '''
                swaccess: "rw"
                hwaccess: "hro"
                resval: "0"
            },
            {
                bits: "3"
                name: oen
                desc: '''
                     Output enable signal, active low
                '''
                swaccess: "rw"
                hwaccess: "hro"
                resval: "1"
            },
            {
                bits: "4"
                name: puen
                desc: '''
                     Pull-Up enable signal, active low
                '''
                swaccess: "rw"
                hwaccess: "hro"
                resval: "1"
            },
            {
                bits: "5"
                name: slw
                desc: '''
                     
                '''
                swaccess: "rw"
                hwaccess: "hro"
                resval: "0"
            },
            {
                bits: "6"
                name: smt
                desc: '''
                     Schmit trigger enable
                '''
                swaccess: "rw"
                hwaccess: "hro"
                resval: "0"
            },
          ]
      }

       {
          name: A_01_MUX_SEL
          desc: '''
              Pad signal port multiplex selection for pad a_01. The programmed value defines which port
              is connected to the pad.
          '''
          swaccess: "rw"
          hwaccess: "hro"
          resval: 0
          fields: [
              {
                  bits: "0:0"
                  enum: [
                      { value: "0", name: "register", desc: "Connects the Pad to the internal configuration register."}
                      { value: "1", name: "port_i2c0_i2c_sda", desc: "Connect port i2c_sda from port group i2c0 to this pad." }
                  ]
              }
          ]
      }

      {
          name: A_02_CFG
          desc: '''
            Pad signal configuration.
          '''
          swaccess: "rw"
          fields: [
            {
                bits: "0"
                name: chip2pad
                desc: '''
                     The signal that connects to the pads TX driver
                '''
                swaccess: "rw"
                hwaccess: "hro"
                resval: "0"
            },
            {
                bits: "2:1"
                name: drv
                desc: '''
                     Driving strength
                '''
                swaccess: "rw"
                hwaccess: "hro"
                resval: "0"
            },
            {
                bits: "3"
                name: oen
                desc: '''
                     Output enable signal, active low
                '''
                swaccess: "rw"
                hwaccess: "hro"
                resval: "1"
            },
            {
                bits: "4"
                name: puen
                desc: '''
                     Pull-Up enable signal, active low
                '''
                swaccess: "rw"
                hwaccess: "hro"
                resval: "1"
            },
            {
                bits: "5"
                name: slw
                desc: '''
                     
                '''
                swaccess: "rw"
                hwaccess: "hro"
                resval: "0"
            },
            {
                bits: "6"
                name: smt
                desc: '''
                     Schmit trigger enable
                '''
                swaccess: "rw"
                hwaccess: "hro"
                resval: "0"
            },
          ]
      }

       {
          name: A_02_MUX_SEL
          desc: '''
              Pad signal port multiplex selection for pad a_02. The programmed value defines which port
              is connected to the pad.
          '''
          swaccess: "rw"
          hwaccess: "hro"
          resval: 0
          fields: [
              {
                  bits: "0:0"
                  enum: [
                      { value: "0", name: "register", desc: "Connects the Pad to the internal configuration register."}
                      { value: "1", name: "port_spi0_spi_sck", desc: "Connect port spi_sck from port group spi0 to this pad." }
                  ]
              }
          ]
      }

      {
          name: A_03_CFG
          desc: '''
            Pad signal configuration.
          '''
          swaccess: "rw"
          fields: [
            {
                bits: "0"
                name: chip2pad
                desc: '''
                     The signal that connects to the pads TX driver
                '''
                swaccess: "rw"
                hwaccess: "hro"
                resval: "0"
            },
            {
                bits: "2:1"
                name: drv
                desc: '''
                     Driving strength
                '''
                swaccess: "rw"
                hwaccess: "hro"
                resval: "0"
            },
            {
                bits: "3"
                name: oen
                desc: '''
                     Output enable signal, active low
                '''
                swaccess: "rw"
                hwaccess: "hro"
                resval: "1"
            },
            {
                bits: "4"
                name: puen
                desc: '''
                     Pull-Up enable signal, active low
                '''
                swaccess: "rw"
                hwaccess: "hro"
                resval: "1"
            },
            {
                bits: "5"
                name: slw
                desc: '''
                     
                '''
                swaccess: "rw"
                hwaccess: "hro"
                resval: "0"
            },
            {
                bits: "6"
                name: smt
                desc: '''
                     Schmit trigger enable
                '''
                swaccess: "rw"
                hwaccess: "hro"
                resval: "0"
            },
          ]
      }

       {
          name: A_03_MUX_SEL
          desc: '''
              Pad signal port multiplex selection for pad a_03. The programmed value defines which port
              is connected to the pad.
          '''
          swaccess: "rw"
          hwaccess: "hro"
          resval: 0
          fields: [
              {
                  bits: "0:0"
                  enum: [
                      { value: "0", name: "register", desc: "Connects the Pad to the internal configuration register."}
                      { value: "1", name: "port_spi0_spi_cs0", desc: "Connect port spi_cs0 from port group spi0 to this pad." }
                  ]
              }
          ]
      }

      {
          name: A_04_CFG
          desc: '''
            Pad signal configuration.
          '''
          swaccess: "rw"
          fields: [
            {
                bits: "0"
                name: chip2pad
                desc: '''
                     The signal that connects to the pads TX driver
                '''
                swaccess: "rw"
                hwaccess: "hro"
                resval: "0"
            },
            {
                bits: "2:1"
                name: drv
                desc: '''
                     Driving strength
                '''
                swaccess: "rw"
                hwaccess: "hro"
                resval: "0"
            },
            {
                bits: "3"
                name: oen
                desc: '''
                     Output enable signal, active low
                '''
                swaccess: "rw"
                hwaccess: "hro"
                resval: "1"
            },
            {
                bits: "4"
                name: puen
                desc: '''
                     Pull-Up enable signal, active low
                '''
                swaccess: "rw"
                hwaccess: "hro"
                resval: "1"
            },
            {
                bits: "5"
                name: slw
                desc: '''
                     
                '''
                swaccess: "rw"
                hwaccess: "hro"
                resval: "0"
            },
            {
                bits: "6"
                name: smt
                desc: '''
                     Schmit trigger enable
                '''
                swaccess: "rw"
                hwaccess: "hro"
                resval: "0"
            },
          ]
      }

       {
          name: A_04_MUX_SEL
          desc: '''
              Pad signal port multiplex selection for pad a_04. The programmed value defines which port
              is connected to the pad.
          '''
          swaccess: "rw"
          hwaccess: "hro"
          resval: 0
          fields: [
              {
                  bits: "0:0"
                  enum: [
                      { value: "0", name: "register", desc: "Connects the Pad to the internal configuration register."}
                      { value: "1", name: "port_spi0_spi_miso", desc: "Connect port spi_miso from port group spi0 to this pad." }
                  ]
              }
          ]
      }

      {
          name: A_05_CFG
          desc: '''
            Pad signal configuration.
          '''
          swaccess: "rw"
          fields: [
            {
                bits: "0"
                name: chip2pad
                desc: '''
                     The signal that connects to the pads TX driver
                '''
                swaccess: "rw"
                hwaccess: "hro"
                resval: "0"
            },
            {
                bits: "2:1"
                name: drv
                desc: '''
                     Driving strength
                '''
                swaccess: "rw"
                hwaccess: "hro"
                resval: "0"
            },
            {
                bits: "3"
                name: oen
                desc: '''
                     Output enable signal, active low
                '''
                swaccess: "rw"
                hwaccess: "hro"
                resval: "1"
            },
            {
                bits: "4"
                name: puen
                desc: '''
                     Pull-Up enable signal, active low
                '''
                swaccess: "rw"
                hwaccess: "hro"
                resval: "1"
            },
            {
                bits: "5"
                name: slw
                desc: '''
                     
                '''
                swaccess: "rw"
                hwaccess: "hro"
                resval: "0"
            },
            {
                bits: "6"
                name: smt
                desc: '''
                     Schmit trigger enable
                '''
                swaccess: "rw"
                hwaccess: "hro"
                resval: "0"
            },
          ]
      }

       {
          name: A_05_MUX_SEL
          desc: '''
              Pad signal port multiplex selection for pad a_05. The programmed value defines which port
              is connected to the pad.
          '''
          swaccess: "rw"
          hwaccess: "hro"
          resval: 0
          fields: [
              {
                  bits: "0:0"
                  enum: [
                      { value: "0", name: "register", desc: "Connects the Pad to the internal configuration register."}
                      { value: "1", name: "port_spi0_spi_mosi", desc: "Connect port spi_mosi from port group spi0 to this pad." }
                  ]
              }
          ]
      }

      {
          name: A_06_CFG
          desc: '''
            Pad signal configuration.
          '''
          swaccess: "rw"
          fields: [
            {
                bits: "0"
                name: chip2pad
                desc: '''
                     The signal that connects to the pads TX driver
                '''
                swaccess: "rw"
                hwaccess: "hro"
                resval: "0"
            },
            {
                bits: "2:1"
                name: drv
                desc: '''
                     Driving strength
                '''
                swaccess: "rw"
                hwaccess: "hro"
                resval: "0"
            },
            {
                bits: "3"
                name: oen
                desc: '''
                     Output enable signal, active low
                '''
                swaccess: "rw"
                hwaccess: "hro"
                resval: "1"
            },
            {
                bits: "4"
                name: puen
                desc: '''
                     Pull-Up enable signal, active low
                '''
                swaccess: "rw"
                hwaccess: "hro"
                resval: "1"
            },
            {
                bits: "5"
                name: slw
                desc: '''
                     
                '''
                swaccess: "rw"
                hwaccess: "hro"
                resval: "0"
            },
            {
                bits: "6"
                name: smt
                desc: '''
                     Schmit trigger enable
                '''
                swaccess: "rw"
                hwaccess: "hro"
                resval: "0"
            },
          ]
      }

       {
          name: A_06_MUX_SEL
          desc: '''
              Pad signal port multiplex selection for pad a_06. The programmed value defines which port
              is connected to the pad.
          '''
          swaccess: "rw"
          hwaccess: "hro"
          resval: 0
          fields: [
              {
                  bits: "0:0"
                  enum: [
                      { value: "0", name: "register", desc: "Connects the Pad to the internal configuration register."}
                      { value: "1", name: "port_spi1_spi_sck", desc: "Connect port spi_sck from port group spi1 to this pad." }
                  ]
              }
          ]
      }

      {
          name: A_07_CFG
          desc: '''
            Pad signal configuration.
          '''
          swaccess: "rw"
          fields: [
            {
                bits: "0"
                name: chip2pad
                desc: '''
                     The signal that connects to the pads TX driver
                '''
                swaccess: "rw"
                hwaccess: "hro"
                resval: "0"
            },
            {
                bits: "2:1"
                name: drv
                desc: '''
                     Driving strength
                '''
                swaccess: "rw"
                hwaccess: "hro"
                resval: "0"
            },
            {
                bits: "3"
                name: oen
                desc: '''
                     Output enable signal, active low
                '''
                swaccess: "rw"
                hwaccess: "hro"
                resval: "1"
            },
            {
                bits: "4"
                name: puen
                desc: '''
                     Pull-Up enable signal, active low
                '''
                swaccess: "rw"
                hwaccess: "hro"
                resval: "1"
            },
            {
                bits: "5"
                name: slw
                desc: '''
                     
                '''
                swaccess: "rw"
                hwaccess: "hro"
                resval: "0"
            },
            {
                bits: "6"
                name: smt
                desc: '''
                     Schmit trigger enable
                '''
                swaccess: "rw"
                hwaccess: "hro"
                resval: "0"
            },
          ]
      }

       {
          name: A_07_MUX_SEL
          desc: '''
              Pad signal port multiplex selection for pad a_07. The programmed value defines which port
              is connected to the pad.
          '''
          swaccess: "rw"
          hwaccess: "hro"
          resval: 0
          fields: [
              {
                  bits: "0:0"
                  enum: [
                      { value: "0", name: "register", desc: "Connects the Pad to the internal configuration register."}
                      { value: "1", name: "port_spi1_spi_cs0", desc: "Connect port spi_cs0 from port group spi1 to this pad." }
                  ]
              }
          ]
      }

      {
          name: A_08_CFG
          desc: '''
            Pad signal configuration.
          '''
          swaccess: "rw"
          fields: [
            {
                bits: "0"
                name: chip2pad
                desc: '''
                     The signal that connects to the pads TX driver
                '''
                swaccess: "rw"
                hwaccess: "hro"
                resval: "0"
            },
            {
                bits: "2:1"
                name: drv
                desc: '''
                     Driving strength
                '''
                swaccess: "rw"
                hwaccess: "hro"
                resval: "0"
            },
            {
                bits: "3"
                name: oen
                desc: '''
                     Output enable signal, active low
                '''
                swaccess: "rw"
                hwaccess: "hro"
                resval: "1"
            },
            {
                bits: "4"
                name: puen
                desc: '''
                     Pull-Up enable signal, active low
                '''
                swaccess: "rw"
                hwaccess: "hro"
                resval: "1"
            },
            {
                bits: "5"
                name: slw
                desc: '''
                     
                '''
                swaccess: "rw"
                hwaccess: "hro"
                resval: "0"
            },
            {
                bits: "6"
                name: smt
                desc: '''
                     Schmit trigger enable
                '''
                swaccess: "rw"
                hwaccess: "hro"
                resval: "0"
            },
          ]
      }

       {
          name: A_08_MUX_SEL
          desc: '''
              Pad signal port multiplex selection for pad a_08. The programmed value defines which port
              is connected to the pad.
          '''
          swaccess: "rw"
          hwaccess: "hro"
          resval: 0
          fields: [
              {
                  bits: "0:0"
                  enum: [
                      { value: "0", name: "register", desc: "Connects the Pad to the internal configuration register."}
                      { value: "1", name: "port_spi1_spi_miso", desc: "Connect port spi_miso from port group spi1 to this pad." }
                  ]
              }
          ]
      }

      {
          name: A_09_CFG
          desc: '''
            Pad signal configuration.
          '''
          swaccess: "rw"
          fields: [
            {
                bits: "0"
                name: chip2pad
                desc: '''
                     The signal that connects to the pads TX driver
                '''
                swaccess: "rw"
                hwaccess: "hro"
                resval: "0"
            },
            {
                bits: "2:1"
                name: drv
                desc: '''
                     Driving strength
                '''
                swaccess: "rw"
                hwaccess: "hro"
                resval: "0"
            },
            {
                bits: "3"
                name: oen
                desc: '''
                     Output enable signal, active low
                '''
                swaccess: "rw"
                hwaccess: "hro"
                resval: "1"
            },
            {
                bits: "4"
                name: puen
                desc: '''
                     Pull-Up enable signal, active low
                '''
                swaccess: "rw"
                hwaccess: "hro"
                resval: "1"
            },
            {
                bits: "5"
                name: slw
                desc: '''
                     
                '''
                swaccess: "rw"
                hwaccess: "hro"
                resval: "0"
            },
            {
                bits: "6"
                name: smt
                desc: '''
                     Schmit trigger enable
                '''
                swaccess: "rw"
                hwaccess: "hro"
                resval: "0"
            },
          ]
      }

       {
          name: A_09_MUX_SEL
          desc: '''
              Pad signal port multiplex selection for pad a_09. The programmed value defines which port
              is connected to the pad.
          '''
          swaccess: "rw"
          hwaccess: "hro"
          resval: 0
          fields: [
              {
                  bits: "0:0"
                  enum: [
                      { value: "0", name: "register", desc: "Connects the Pad to the internal configuration register."}
                      { value: "1", name: "port_spi1_spi_mosi", desc: "Connect port spi_mosi from port group spi1 to this pad." }
                  ]
              }
          ]
      }

      {
          name: A_10_CFG
          desc: '''
            Pad signal configuration.
          '''
          swaccess: "rw"
          fields: [
            {
                bits: "0"
                name: chip2pad
                desc: '''
                     The signal that connects to the pads TX driver
                '''
                swaccess: "rw"
                hwaccess: "hro"
                resval: "0"
            },
            {
                bits: "2:1"
                name: drv
                desc: '''
                     Driving strength
                '''
                swaccess: "rw"
                hwaccess: "hro"
                resval: "0"
            },
            {
                bits: "3"
                name: oen
                desc: '''
                     Output enable signal, active low
                '''
                swaccess: "rw"
                hwaccess: "hro"
                resval: "1"
            },
            {
                bits: "4"
                name: puen
                desc: '''
                     Pull-Up enable signal, active low
                '''
                swaccess: "rw"
                hwaccess: "hro"
                resval: "1"
            },
            {
                bits: "5"
                name: slw
                desc: '''
                     
                '''
                swaccess: "rw"
                hwaccess: "hro"
                resval: "0"
            },
            {
                bits: "6"
                name: smt
                desc: '''
                     Schmit trigger enable
                '''
                swaccess: "rw"
                hwaccess: "hro"
                resval: "0"
            },
          ]
      }

       {
          name: A_10_MUX_SEL
          desc: '''
              Pad signal port multiplex selection for pad a_10. The programmed value defines which port
              is connected to the pad.
          '''
          swaccess: "rw"
          hwaccess: "hro"
          resval: 0
          fields: [
              {
                  bits: "0:0"
                  enum: [
                      { value: "0", name: "register", desc: "Connects the Pad to the internal configuration register."}
                      { value: "1", name: "port_spi2_spi_sck", desc: "Connect port spi_sck from port group spi2 to this pad." }
                  ]
              }
          ]
      }

      {
          name: A_11_CFG
          desc: '''
            Pad signal configuration.
          '''
          swaccess: "rw"
          fields: [
            {
                bits: "0"
                name: chip2pad
                desc: '''
                     The signal that connects to the pads TX driver
                '''
                swaccess: "rw"
                hwaccess: "hro"
                resval: "0"
            },
            {
                bits: "2:1"
                name: drv
                desc: '''
                     Driving strength
                '''
                swaccess: "rw"
                hwaccess: "hro"
                resval: "0"
            },
            {
                bits: "3"
                name: oen
                desc: '''
                     Output enable signal, active low
                '''
                swaccess: "rw"
                hwaccess: "hro"
                resval: "1"
            },
            {
                bits: "4"
                name: puen
                desc: '''
                     Pull-Up enable signal, active low
                '''
                swaccess: "rw"
                hwaccess: "hro"
                resval: "1"
            },
            {
                bits: "5"
                name: slw
                desc: '''
                     
                '''
                swaccess: "rw"
                hwaccess: "hro"
                resval: "0"
            },
            {
                bits: "6"
                name: smt
                desc: '''
                     Schmit trigger enable
                '''
                swaccess: "rw"
                hwaccess: "hro"
                resval: "0"
            },
          ]
      }

       {
          name: A_11_MUX_SEL
          desc: '''
              Pad signal port multiplex selection for pad a_11. The programmed value defines which port
              is connected to the pad.
          '''
          swaccess: "rw"
          hwaccess: "hro"
          resval: 0
          fields: [
              {
                  bits: "0:0"
                  enum: [
                      { value: "0", name: "register", desc: "Connects the Pad to the internal configuration register."}
                      { value: "1", name: "port_spi2_spi_cs0", desc: "Connect port spi_cs0 from port group spi2 to this pad." }
                  ]
              }
          ]
      }

      {
          name: A_12_CFG
          desc: '''
            Pad signal configuration.
          '''
          swaccess: "rw"
          fields: [
            {
                bits: "0"
                name: chip2pad
                desc: '''
                     The signal that connects to the pads TX driver
                '''
                swaccess: "rw"
                hwaccess: "hro"
                resval: "0"
            },
            {
                bits: "2:1"
                name: drv
                desc: '''
                     Driving strength
                '''
                swaccess: "rw"
                hwaccess: "hro"
                resval: "0"
            },
            {
                bits: "3"
                name: oen
                desc: '''
                     Output enable signal, active low
                '''
                swaccess: "rw"
                hwaccess: "hro"
                resval: "1"
            },
            {
                bits: "4"
                name: puen
                desc: '''
                     Pull-Up enable signal, active low
                '''
                swaccess: "rw"
                hwaccess: "hro"
                resval: "1"
            },
            {
                bits: "5"
                name: slw
                desc: '''
                     
                '''
                swaccess: "rw"
                hwaccess: "hro"
                resval: "0"
            },
            {
                bits: "6"
                name: smt
                desc: '''
                     Schmit trigger enable
                '''
                swaccess: "rw"
                hwaccess: "hro"
                resval: "0"
            },
          ]
      }

       {
          name: A_12_MUX_SEL
          desc: '''
              Pad signal port multiplex selection for pad a_12. The programmed value defines which port
              is connected to the pad.
          '''
          swaccess: "rw"
          hwaccess: "hro"
          resval: 0
          fields: [
              {
                  bits: "0:0"
                  enum: [
                      { value: "0", name: "register", desc: "Connects the Pad to the internal configuration register."}
                      { value: "1", name: "port_spi2_spi_miso", desc: "Connect port spi_miso from port group spi2 to this pad." }
                  ]
              }
          ]
      }

      {
          name: A_13_CFG
          desc: '''
            Pad signal configuration.
          '''
          swaccess: "rw"
          fields: [
            {
                bits: "0"
                name: chip2pad
                desc: '''
                     The signal that connects to the pads TX driver
                '''
                swaccess: "rw"
                hwaccess: "hro"
                resval: "0"
            },
            {
                bits: "2:1"
                name: drv
                desc: '''
                     Driving strength
                '''
                swaccess: "rw"
                hwaccess: "hro"
                resval: "0"
            },
            {
                bits: "3"
                name: oen
                desc: '''
                     Output enable signal, active low
                '''
                swaccess: "rw"
                hwaccess: "hro"
                resval: "1"
            },
            {
                bits: "4"
                name: puen
                desc: '''
                     Pull-Up enable signal, active low
                '''
                swaccess: "rw"
                hwaccess: "hro"
                resval: "1"
            },
            {
                bits: "5"
                name: slw
                desc: '''
                     
                '''
                swaccess: "rw"
                hwaccess: "hro"
                resval: "0"
            },
            {
                bits: "6"
                name: smt
                desc: '''
                     Schmit trigger enable
                '''
                swaccess: "rw"
                hwaccess: "hro"
                resval: "0"
            },
          ]
      }

       {
          name: A_13_MUX_SEL
          desc: '''
              Pad signal port multiplex selection for pad a_13. The programmed value defines which port
              is connected to the pad.
          '''
          swaccess: "rw"
          hwaccess: "hro"
          resval: 0
          fields: [
              {
                  bits: "0:0"
                  enum: [
                      { value: "0", name: "register", desc: "Connects the Pad to the internal configuration register."}
                      { value: "1", name: "port_spi2_spi_mosi", desc: "Connect port spi_mosi from port group spi2 to this pad." }
                  ]
              }
          ]
      }

      {
          name: A_14_CFG
          desc: '''
            Pad signal configuration.
          '''
          swaccess: "rw"
          fields: [
            {
                bits: "0"
                name: chip2pad
                desc: '''
                     The signal that connects to the pads TX driver
                '''
                swaccess: "rw"
                hwaccess: "hro"
                resval: "0"
            },
            {
                bits: "2:1"
                name: drv
                desc: '''
                     Driving strength
                '''
                swaccess: "rw"
                hwaccess: "hro"
                resval: "0"
            },
            {
                bits: "3"
                name: oen
                desc: '''
                     Output enable signal, active low
                '''
                swaccess: "rw"
                hwaccess: "hro"
                resval: "1"
            },
            {
                bits: "4"
                name: puen
                desc: '''
                     Pull-Up enable signal, active low
                '''
                swaccess: "rw"
                hwaccess: "hro"
                resval: "1"
            },
            {
                bits: "5"
                name: slw
                desc: '''
                     
                '''
                swaccess: "rw"
                hwaccess: "hro"
                resval: "0"
            },
            {
                bits: "6"
                name: smt
                desc: '''
                     Schmit trigger enable
                '''
                swaccess: "rw"
                hwaccess: "hro"
                resval: "0"
            },
          ]
      }

       {
          name: A_14_MUX_SEL
          desc: '''
              Pad signal port multiplex selection for pad a_14. The programmed value defines which port
              is connected to the pad.
          '''
          swaccess: "rw"
          hwaccess: "hro"
          resval: 0
          fields: [
              {
                  bits: "0:0"
                  enum: [
                      { value: "0", name: "register", desc: "Connects the Pad to the internal configuration register."}
                      { value: "1", name: "port_spi3_spi_sck", desc: "Connect port spi_sck from port group spi3 to this pad." }
                  ]
              }
          ]
      }

      {
          name: A_15_CFG
          desc: '''
            Pad signal configuration.
          '''
          swaccess: "rw"
          fields: [
            {
                bits: "0"
                name: chip2pad
                desc: '''
                     The signal that connects to the pads TX driver
                '''
                swaccess: "rw"
                hwaccess: "hro"
                resval: "0"
            },
            {
                bits: "2:1"
                name: drv
                desc: '''
                     Driving strength
                '''
                swaccess: "rw"
                hwaccess: "hro"
                resval: "0"
            },
            {
                bits: "3"
                name: oen
                desc: '''
                     Output enable signal, active low
                '''
                swaccess: "rw"
                hwaccess: "hro"
                resval: "1"
            },
            {
                bits: "4"
                name: puen
                desc: '''
                     Pull-Up enable signal, active low
                '''
                swaccess: "rw"
                hwaccess: "hro"
                resval: "1"
            },
            {
                bits: "5"
                name: slw
                desc: '''
                     
                '''
                swaccess: "rw"
                hwaccess: "hro"
                resval: "0"
            },
            {
                bits: "6"
                name: smt
                desc: '''
                     Schmit trigger enable
                '''
                swaccess: "rw"
                hwaccess: "hro"
                resval: "0"
            },
          ]
      }

       {
          name: A_15_MUX_SEL
          desc: '''
              Pad signal port multiplex selection for pad a_15. The programmed value defines which port
              is connected to the pad.
          '''
          swaccess: "rw"
          hwaccess: "hro"
          resval: 0
          fields: [
              {
                  bits: "0:0"
                  enum: [
                      { value: "0", name: "register", desc: "Connects the Pad to the internal configuration register."}
                      { value: "1", name: "port_spi3_spi_cs0", desc: "Connect port spi_cs0 from port group spi3 to this pad." }
                  ]
              }
          ]
      }

      {
          name: A_16_CFG
          desc: '''
            Pad signal configuration.
          '''
          swaccess: "rw"
          fields: [
            {
                bits: "0"
                name: chip2pad
                desc: '''
                     The signal that connects to the pads TX driver
                '''
                swaccess: "rw"
                hwaccess: "hro"
                resval: "0"
            },
            {
                bits: "2:1"
                name: drv
                desc: '''
                     Driving strength
                '''
                swaccess: "rw"
                hwaccess: "hro"
                resval: "0"
            },
            {
                bits: "3"
                name: oen
                desc: '''
                     Output enable signal, active low
                '''
                swaccess: "rw"
                hwaccess: "hro"
                resval: "1"
            },
            {
                bits: "4"
                name: puen
                desc: '''
                     Pull-Up enable signal, active low
                '''
                swaccess: "rw"
                hwaccess: "hro"
                resval: "1"
            },
            {
                bits: "5"
                name: slw
                desc: '''
                     
                '''
                swaccess: "rw"
                hwaccess: "hro"
                resval: "0"
            },
            {
                bits: "6"
                name: smt
                desc: '''
                     Schmit trigger enable
                '''
                swaccess: "rw"
                hwaccess: "hro"
                resval: "0"
            },
          ]
      }

       {
          name: A_16_MUX_SEL
          desc: '''
              Pad signal port multiplex selection for pad a_16. The programmed value defines which port
              is connected to the pad.
          '''
          swaccess: "rw"
          hwaccess: "hro"
          resval: 0
          fields: [
              {
                  bits: "0:0"
                  enum: [
                      { value: "0", name: "register", desc: "Connects the Pad to the internal configuration register."}
                      { value: "1", name: "port_spi3_spi_miso", desc: "Connect port spi_miso from port group spi3 to this pad." }
                  ]
              }
          ]
      }

      {
          name: A_17_CFG
          desc: '''
            Pad signal configuration.
          '''
          swaccess: "rw"
          fields: [
            {
                bits: "0"
                name: chip2pad
                desc: '''
                     The signal that connects to the pads TX driver
                '''
                swaccess: "rw"
                hwaccess: "hro"
                resval: "0"
            },
            {
                bits: "2:1"
                name: drv
                desc: '''
                     Driving strength
                '''
                swaccess: "rw"
                hwaccess: "hro"
                resval: "0"
            },
            {
                bits: "3"
                name: oen
                desc: '''
                     Output enable signal, active low
                '''
                swaccess: "rw"
                hwaccess: "hro"
                resval: "1"
            },
            {
                bits: "4"
                name: puen
                desc: '''
                     Pull-Up enable signal, active low
                '''
                swaccess: "rw"
                hwaccess: "hro"
                resval: "1"
            },
            {
                bits: "5"
                name: slw
                desc: '''
                     
                '''
                swaccess: "rw"
                hwaccess: "hro"
                resval: "0"
            },
            {
                bits: "6"
                name: smt
                desc: '''
                     Schmit trigger enable
                '''
                swaccess: "rw"
                hwaccess: "hro"
                resval: "0"
            },
          ]
      }

       {
          name: A_17_MUX_SEL
          desc: '''
              Pad signal port multiplex selection for pad a_17. The programmed value defines which port
              is connected to the pad.
          '''
          swaccess: "rw"
          hwaccess: "hro"
          resval: 0
          fields: [
              {
                  bits: "0:0"
                  enum: [
                      { value: "0", name: "register", desc: "Connects the Pad to the internal configuration register."}
                      { value: "1", name: "port_spi3_spi_mosi", desc: "Connect port spi_mosi from port group spi3 to this pad." }
                  ]
              }
          ]
      }

      {
          name: A_18_CFG
          desc: '''
            Pad signal configuration.
          '''
          swaccess: "rw"
          fields: [
            {
                bits: "0"
                name: chip2pad
                desc: '''
                     The signal that connects to the pads TX driver
                '''
                swaccess: "rw"
                hwaccess: "hro"
                resval: "0"
            },
            {
                bits: "2:1"
                name: drv
                desc: '''
                     Driving strength
                '''
                swaccess: "rw"
                hwaccess: "hro"
                resval: "0"
            },
            {
                bits: "3"
                name: oen
                desc: '''
                     Output enable signal, active low
                '''
                swaccess: "rw"
                hwaccess: "hro"
                resval: "1"
            },
            {
                bits: "4"
                name: puen
                desc: '''
                     Pull-Up enable signal, active low
                '''
                swaccess: "rw"
                hwaccess: "hro"
                resval: "1"
            },
            {
                bits: "5"
                name: slw
                desc: '''
                     
                '''
                swaccess: "rw"
                hwaccess: "hro"
                resval: "0"
            },
            {
                bits: "6"
                name: smt
                desc: '''
                     Schmit trigger enable
                '''
                swaccess: "rw"
                hwaccess: "hro"
                resval: "0"
            },
          ]
      }

       {
          name: A_18_MUX_SEL
          desc: '''
              Pad signal port multiplex selection for pad a_18. The programmed value defines which port
              is connected to the pad.
          '''
          swaccess: "rw"
          hwaccess: "hro"
          resval: 0
          fields: [
              {
                  bits: "0:0"
                  enum: [
                      { value: "0", name: "register", desc: "Connects the Pad to the internal configuration register."}
                      { value: "1", name: "port_sdio0_sdio_data0", desc: "Connect port sdio_data0 from port group sdio0 to this pad." }
                  ]
              }
          ]
      }

      {
          name: A_19_CFG
          desc: '''
            Pad signal configuration.
          '''
          swaccess: "rw"
          fields: [
            {
                bits: "0"
                name: chip2pad
                desc: '''
                     The signal that connects to the pads TX driver
                '''
                swaccess: "rw"
                hwaccess: "hro"
                resval: "0"
            },
            {
                bits: "2:1"
                name: drv
                desc: '''
                     Driving strength
                '''
                swaccess: "rw"
                hwaccess: "hro"
                resval: "0"
            },
            {
                bits: "3"
                name: oen
                desc: '''
                     Output enable signal, active low
                '''
                swaccess: "rw"
                hwaccess: "hro"
                resval: "1"
            },
            {
                bits: "4"
                name: puen
                desc: '''
                     Pull-Up enable signal, active low
                '''
                swaccess: "rw"
                hwaccess: "hro"
                resval: "1"
            },
            {
                bits: "5"
                name: slw
                desc: '''
                     
                '''
                swaccess: "rw"
                hwaccess: "hro"
                resval: "0"
            },
            {
                bits: "6"
                name: smt
                desc: '''
                     Schmit trigger enable
                '''
                swaccess: "rw"
                hwaccess: "hro"
                resval: "0"
            },
          ]
      }

       {
          name: A_19_MUX_SEL
          desc: '''
              Pad signal port multiplex selection for pad a_19. The programmed value defines which port
              is connected to the pad.
          '''
          swaccess: "rw"
          hwaccess: "hro"
          resval: 0
          fields: [
              {
                  bits: "0:0"
                  enum: [
                      { value: "0", name: "register", desc: "Connects the Pad to the internal configuration register."}
                      { value: "1", name: "port_sdio0_sdio_data1", desc: "Connect port sdio_data1 from port group sdio0 to this pad." }
                  ]
              }
          ]
      }

      {
          name: A_20_CFG
          desc: '''
            Pad signal configuration.
          '''
          swaccess: "rw"
          fields: [
            {
                bits: "0"
                name: chip2pad
                desc: '''
                     The signal that connects to the pads TX driver
                '''
                swaccess: "rw"
                hwaccess: "hro"
                resval: "0"
            },
            {
                bits: "2:1"
                name: drv
                desc: '''
                     Driving strength
                '''
                swaccess: "rw"
                hwaccess: "hro"
                resval: "0"
            },
            {
                bits: "3"
                name: oen
                desc: '''
                     Output enable signal, active low
                '''
                swaccess: "rw"
                hwaccess: "hro"
                resval: "1"
            },
            {
                bits: "4"
                name: puen
                desc: '''
                     Pull-Up enable signal, active low
                '''
                swaccess: "rw"
                hwaccess: "hro"
                resval: "1"
            },
            {
                bits: "5"
                name: slw
                desc: '''
                     
                '''
                swaccess: "rw"
                hwaccess: "hro"
                resval: "0"
            },
            {
                bits: "6"
                name: smt
                desc: '''
                     Schmit trigger enable
                '''
                swaccess: "rw"
                hwaccess: "hro"
                resval: "0"
            },
          ]
      }

       {
          name: A_20_MUX_SEL
          desc: '''
              Pad signal port multiplex selection for pad a_20. The programmed value defines which port
              is connected to the pad.
          '''
          swaccess: "rw"
          hwaccess: "hro"
          resval: 0
          fields: [
              {
                  bits: "0:0"
                  enum: [
                      { value: "0", name: "register", desc: "Connects the Pad to the internal configuration register."}
                      { value: "1", name: "port_sdio0_sdio_data2", desc: "Connect port sdio_data2 from port group sdio0 to this pad." }
                  ]
              }
          ]
      }

      {
          name: A_21_CFG
          desc: '''
            Pad signal configuration.
          '''
          swaccess: "rw"
          fields: [
            {
                bits: "0"
                name: chip2pad
                desc: '''
                     The signal that connects to the pads TX driver
                '''
                swaccess: "rw"
                hwaccess: "hro"
                resval: "0"
            },
            {
                bits: "2:1"
                name: drv
                desc: '''
                     Driving strength
                '''
                swaccess: "rw"
                hwaccess: "hro"
                resval: "0"
            },
            {
                bits: "3"
                name: oen
                desc: '''
                     Output enable signal, active low
                '''
                swaccess: "rw"
                hwaccess: "hro"
                resval: "1"
            },
            {
                bits: "4"
                name: puen
                desc: '''
                     Pull-Up enable signal, active low
                '''
                swaccess: "rw"
                hwaccess: "hro"
                resval: "1"
            },
            {
                bits: "5"
                name: slw
                desc: '''
                     
                '''
                swaccess: "rw"
                hwaccess: "hro"
                resval: "0"
            },
            {
                bits: "6"
                name: smt
                desc: '''
                     Schmit trigger enable
                '''
                swaccess: "rw"
                hwaccess: "hro"
                resval: "0"
            },
          ]
      }

       {
          name: A_21_MUX_SEL
          desc: '''
              Pad signal port multiplex selection for pad a_21. The programmed value defines which port
              is connected to the pad.
          '''
          swaccess: "rw"
          hwaccess: "hro"
          resval: 0
          fields: [
              {
                  bits: "0:0"
                  enum: [
                      { value: "0", name: "register", desc: "Connects the Pad to the internal configuration register."}
                      { value: "1", name: "port_sdio0_sdio_data3", desc: "Connect port sdio_data3 from port group sdio0 to this pad." }
                  ]
              }
          ]
      }

      {
          name: A_22_CFG
          desc: '''
            Pad signal configuration.
          '''
          swaccess: "rw"
          fields: [
            {
                bits: "0"
                name: chip2pad
                desc: '''
                     The signal that connects to the pads TX driver
                '''
                swaccess: "rw"
                hwaccess: "hro"
                resval: "0"
            },
            {
                bits: "2:1"
                name: drv
                desc: '''
                     Driving strength
                '''
                swaccess: "rw"
                hwaccess: "hro"
                resval: "0"
            },
            {
                bits: "3"
                name: oen
                desc: '''
                     Output enable signal, active low
                '''
                swaccess: "rw"
                hwaccess: "hro"
                resval: "1"
            },
            {
                bits: "4"
                name: puen
                desc: '''
                     Pull-Up enable signal, active low
                '''
                swaccess: "rw"
                hwaccess: "hro"
                resval: "1"
            },
            {
                bits: "5"
                name: slw
                desc: '''
                     
                '''
                swaccess: "rw"
                hwaccess: "hro"
                resval: "0"
            },
            {
                bits: "6"
                name: smt
                desc: '''
                     Schmit trigger enable
                '''
                swaccess: "rw"
                hwaccess: "hro"
                resval: "0"
            },
          ]
      }

       {
          name: A_22_MUX_SEL
          desc: '''
              Pad signal port multiplex selection for pad a_22. The programmed value defines which port
              is connected to the pad.
          '''
          swaccess: "rw"
          hwaccess: "hro"
          resval: 0
          fields: [
              {
                  bits: "0:0"
                  enum: [
                      { value: "0", name: "register", desc: "Connects the Pad to the internal configuration register."}
                      { value: "1", name: "port_sdio0_sdio_clk", desc: "Connect port sdio_clk from port group sdio0 to this pad." }
                  ]
              }
          ]
      }

      {
          name: A_23_CFG
          desc: '''
            Pad signal configuration.
          '''
          swaccess: "rw"
          fields: [
            {
                bits: "0"
                name: chip2pad
                desc: '''
                     The signal that connects to the pads TX driver
                '''
                swaccess: "rw"
                hwaccess: "hro"
                resval: "0"
            },
            {
                bits: "2:1"
                name: drv
                desc: '''
                     Driving strength
                '''
                swaccess: "rw"
                hwaccess: "hro"
                resval: "0"
            },
            {
                bits: "3"
                name: oen
                desc: '''
                     Output enable signal, active low
                '''
                swaccess: "rw"
                hwaccess: "hro"
                resval: "1"
            },
            {
                bits: "4"
                name: puen
                desc: '''
                     Pull-Up enable signal, active low
                '''
                swaccess: "rw"
                hwaccess: "hro"
                resval: "1"
            },
            {
                bits: "5"
                name: slw
                desc: '''
                     
                '''
                swaccess: "rw"
                hwaccess: "hro"
                resval: "0"
            },
            {
                bits: "6"
                name: smt
                desc: '''
                     Schmit trigger enable
                '''
                swaccess: "rw"
                hwaccess: "hro"
                resval: "0"
            },
          ]
      }

       {
          name: A_23_MUX_SEL
          desc: '''
              Pad signal port multiplex selection for pad a_23. The programmed value defines which port
              is connected to the pad.
          '''
          swaccess: "rw"
          hwaccess: "hro"
          resval: 0
          fields: [
              {
                  bits: "0:0"
                  enum: [
                      { value: "0", name: "register", desc: "Connects the Pad to the internal configuration register."}
                      { value: "1", name: "port_sdio0_sdio_cmd", desc: "Connect port sdio_cmd from port group sdio0 to this pad." }
                  ]
              }
          ]
      }

      {
          name: A_24_CFG
          desc: '''
            Pad signal configuration.
          '''
          swaccess: "rw"
          fields: [
            {
                bits: "0"
                name: chip2pad
                desc: '''
                     The signal that connects to the pads TX driver
                '''
                swaccess: "rw"
                hwaccess: "hro"
                resval: "0"
            },
            {
                bits: "2:1"
                name: drv
                desc: '''
                     Driving strength
                '''
                swaccess: "rw"
                hwaccess: "hro"
                resval: "0"
            },
            {
                bits: "3"
                name: oen
                desc: '''
                     Output enable signal, active low
                '''
                swaccess: "rw"
                hwaccess: "hro"
                resval: "1"
            },
            {
                bits: "4"
                name: puen
                desc: '''
                     Pull-Up enable signal, active low
                '''
                swaccess: "rw"
                hwaccess: "hro"
                resval: "1"
            },
            {
                bits: "5"
                name: slw
                desc: '''
                     
                '''
                swaccess: "rw"
                hwaccess: "hro"
                resval: "0"
            },
            {
                bits: "6"
                name: smt
                desc: '''
                     Schmit trigger enable
                '''
                swaccess: "rw"
                hwaccess: "hro"
                resval: "0"
            },
          ]
      }

       {
          name: A_24_MUX_SEL
          desc: '''
              Pad signal port multiplex selection for pad a_24. The programmed value defines which port
              is connected to the pad.
          '''
          swaccess: "rw"
          hwaccess: "hro"
          resval: 0
          fields: [
              {
                  bits: "0:0"
                  enum: [
                      { value: "0", name: "register", desc: "Connects the Pad to the internal configuration register."}
                      { value: "1", name: "port_uart0_uart_tx", desc: "Connect port uart_tx from port group uart0 to this pad." }
                  ]
              }
          ]
      }

      {
          name: A_25_CFG
          desc: '''
            Pad signal configuration.
          '''
          swaccess: "rw"
          fields: [
            {
                bits: "0"
                name: chip2pad
                desc: '''
                     The signal that connects to the pads TX driver
                '''
                swaccess: "rw"
                hwaccess: "hro"
                resval: "0"
            },
            {
                bits: "2:1"
                name: drv
                desc: '''
                     Driving strength
                '''
                swaccess: "rw"
                hwaccess: "hro"
                resval: "0"
            },
            {
                bits: "3"
                name: oen
                desc: '''
                     Output enable signal, active low
                '''
                swaccess: "rw"
                hwaccess: "hro"
                resval: "1"
            },
            {
                bits: "4"
                name: puen
                desc: '''
                     Pull-Up enable signal, active low
                '''
                swaccess: "rw"
                hwaccess: "hro"
                resval: "1"
            },
            {
                bits: "5"
                name: slw
                desc: '''
                     
                '''
                swaccess: "rw"
                hwaccess: "hro"
                resval: "0"
            },
            {
                bits: "6"
                name: smt
                desc: '''
                     Schmit trigger enable
                '''
                swaccess: "rw"
                hwaccess: "hro"
                resval: "0"
            },
          ]
      }

       {
          name: A_25_MUX_SEL
          desc: '''
              Pad signal port multiplex selection for pad a_25. The programmed value defines which port
              is connected to the pad.
          '''
          swaccess: "rw"
          hwaccess: "hro"
          resval: 0
          fields: [
              {
                  bits: "0:0"
                  enum: [
                      { value: "0", name: "register", desc: "Connects the Pad to the internal configuration register."}
                      { value: "1", name: "port_uart0_uart_rx", desc: "Connect port uart_rx from port group uart0 to this pad." }
                  ]
              }
          ]
      }

      {
          name: A_26_CFG
          desc: '''
            Pad signal configuration.
          '''
          swaccess: "rw"
          fields: [
            {
                bits: "0"
                name: chip2pad
                desc: '''
                     The signal that connects to the pads TX driver
                '''
                swaccess: "rw"
                hwaccess: "hro"
                resval: "0"
            },
            {
                bits: "2:1"
                name: drv
                desc: '''
                     Driving strength
                '''
                swaccess: "rw"
                hwaccess: "hro"
                resval: "0"
            },
            {
                bits: "3"
                name: oen
                desc: '''
                     Output enable signal, active low
                '''
                swaccess: "rw"
                hwaccess: "hro"
                resval: "1"
            },
            {
                bits: "4"
                name: puen
                desc: '''
                     Pull-Up enable signal, active low
                '''
                swaccess: "rw"
                hwaccess: "hro"
                resval: "1"
            },
            {
                bits: "5"
                name: slw
                desc: '''
                     
                '''
                swaccess: "rw"
                hwaccess: "hro"
                resval: "0"
            },
            {
                bits: "6"
                name: smt
                desc: '''
                     Schmit trigger enable
                '''
                swaccess: "rw"
                hwaccess: "hro"
                resval: "0"
            },
          ]
      }

       {
          name: A_26_MUX_SEL
          desc: '''
              Pad signal port multiplex selection for pad a_26. The programmed value defines which port
              is connected to the pad.
          '''
          swaccess: "rw"
          hwaccess: "hro"
          resval: 0
          fields: [
              {
                  bits: "0:0"
                  enum: [
                      { value: "0", name: "register", desc: "Connects the Pad to the internal configuration register."}
                      { value: "1", name: "port_i2c1_i2c_scl", desc: "Connect port i2c_scl from port group i2c1 to this pad." }
                  ]
              }
          ]
      }

      {
          name: A_27_CFG
          desc: '''
            Pad signal configuration.
          '''
          swaccess: "rw"
          fields: [
            {
                bits: "0"
                name: chip2pad
                desc: '''
                     The signal that connects to the pads TX driver
                '''
                swaccess: "rw"
                hwaccess: "hro"
                resval: "0"
            },
            {
                bits: "2:1"
                name: drv
                desc: '''
                     Driving strength
                '''
                swaccess: "rw"
                hwaccess: "hro"
                resval: "0"
            },
            {
                bits: "3"
                name: oen
                desc: '''
                     Output enable signal, active low
                '''
                swaccess: "rw"
                hwaccess: "hro"
                resval: "1"
            },
            {
                bits: "4"
                name: puen
                desc: '''
                     Pull-Up enable signal, active low
                '''
                swaccess: "rw"
                hwaccess: "hro"
                resval: "1"
            },
            {
                bits: "5"
                name: slw
                desc: '''
                     
                '''
                swaccess: "rw"
                hwaccess: "hro"
                resval: "0"
            },
            {
                bits: "6"
                name: smt
                desc: '''
                     Schmit trigger enable
                '''
                swaccess: "rw"
                hwaccess: "hro"
                resval: "0"
            },
          ]
      }

       {
          name: A_27_MUX_SEL
          desc: '''
              Pad signal port multiplex selection for pad a_27. The programmed value defines which port
              is connected to the pad.
          '''
          swaccess: "rw"
          hwaccess: "hro"
          resval: 0
          fields: [
              {
                  bits: "0:0"
                  enum: [
                      { value: "0", name: "register", desc: "Connects the Pad to the internal configuration register."}
                      { value: "1", name: "port_i2c1_i2c_sda", desc: "Connect port i2c_sda from port group i2c1 to this pad." }
                  ]
              }
          ]
      }

      {
          name: A_28_CFG
          desc: '''
            Pad signal configuration.
          '''
          swaccess: "rw"
          fields: [
            {
                bits: "0"
                name: chip2pad
                desc: '''
                     The signal that connects to the pads TX driver
                '''
                swaccess: "rw"
                hwaccess: "hro"
                resval: "0"
            },
            {
                bits: "2:1"
                name: drv
                desc: '''
                     Driving strength
                '''
                swaccess: "rw"
                hwaccess: "hro"
                resval: "0"
            },
            {
                bits: "3"
                name: oen
                desc: '''
                     Output enable signal, active low
                '''
                swaccess: "rw"
                hwaccess: "hro"
                resval: "1"
            },
            {
                bits: "4"
                name: puen
                desc: '''
                     Pull-Up enable signal, active low
                '''
                swaccess: "rw"
                hwaccess: "hro"
                resval: "1"
            },
            {
                bits: "5"
                name: slw
                desc: '''
                     
                '''
                swaccess: "rw"
                hwaccess: "hro"
                resval: "0"
            },
            {
                bits: "6"
                name: smt
                desc: '''
                     Schmit trigger enable
                '''
                swaccess: "rw"
                hwaccess: "hro"
                resval: "0"
            },
          ]
      }

       {
          name: A_28_MUX_SEL
          desc: '''
              Pad signal port multiplex selection for pad a_28. The programmed value defines which port
              is connected to the pad.
          '''
          swaccess: "rw"
          hwaccess: "hro"
          resval: 0
          fields: [
              {
                  bits: "0:0"
                  enum: [
                      { value: "0", name: "register", desc: "Connects the Pad to the internal configuration register."}
                      { value: "1", name: "port_usart0_uart_tx", desc: "Connect port uart_tx from port group usart0 to this pad." }
                  ]
              }
          ]
      }

      {
          name: A_29_CFG
          desc: '''
            Pad signal configuration.
          '''
          swaccess: "rw"
          fields: [
            {
                bits: "0"
                name: chip2pad
                desc: '''
                     The signal that connects to the pads TX driver
                '''
                swaccess: "rw"
                hwaccess: "hro"
                resval: "0"
            },
            {
                bits: "2:1"
                name: drv
                desc: '''
                     Driving strength
                '''
                swaccess: "rw"
                hwaccess: "hro"
                resval: "0"
            },
            {
                bits: "3"
                name: oen
                desc: '''
                     Output enable signal, active low
                '''
                swaccess: "rw"
                hwaccess: "hro"
                resval: "1"
            },
            {
                bits: "4"
                name: puen
                desc: '''
                     Pull-Up enable signal, active low
                '''
                swaccess: "rw"
                hwaccess: "hro"
                resval: "1"
            },
            {
                bits: "5"
                name: slw
                desc: '''
                     
                '''
                swaccess: "rw"
                hwaccess: "hro"
                resval: "0"
            },
            {
                bits: "6"
                name: smt
                desc: '''
                     Schmit trigger enable
                '''
                swaccess: "rw"
                hwaccess: "hro"
                resval: "0"
            },
          ]
      }

       {
          name: A_29_MUX_SEL
          desc: '''
              Pad signal port multiplex selection for pad a_29. The programmed value defines which port
              is connected to the pad.
          '''
          swaccess: "rw"
          hwaccess: "hro"
          resval: 0
          fields: [
              {
                  bits: "0:0"
                  enum: [
                      { value: "0", name: "register", desc: "Connects the Pad to the internal configuration register."}
                      { value: "1", name: "port_usart0_uart_rx", desc: "Connect port uart_rx from port group usart0 to this pad." }
                  ]
              }
          ]
      }

      {
          name: A_30_CFG
          desc: '''
            Pad signal configuration.
          '''
          swaccess: "rw"
          fields: [
            {
                bits: "0"
                name: chip2pad
                desc: '''
                     The signal that connects to the pads TX driver
                '''
                swaccess: "rw"
                hwaccess: "hro"
                resval: "0"
            },
            {
                bits: "2:1"
                name: drv
                desc: '''
                     Driving strength
                '''
                swaccess: "rw"
                hwaccess: "hro"
                resval: "0"
            },
            {
                bits: "3"
                name: oen
                desc: '''
                     Output enable signal, active low
                '''
                swaccess: "rw"
                hwaccess: "hro"
                resval: "1"
            },
            {
                bits: "4"
                name: puen
                desc: '''
                     Pull-Up enable signal, active low
                '''
                swaccess: "rw"
                hwaccess: "hro"
                resval: "1"
            },
            {
                bits: "5"
                name: slw
                desc: '''
                     
                '''
                swaccess: "rw"
                hwaccess: "hro"
                resval: "0"
            },
            {
                bits: "6"
                name: smt
                desc: '''
                     Schmit trigger enable
                '''
                swaccess: "rw"
                hwaccess: "hro"
                resval: "0"
            },
          ]
      }

       {
          name: A_30_MUX_SEL
          desc: '''
              Pad signal port multiplex selection for pad a_30. The programmed value defines which port
              is connected to the pad.
          '''
          swaccess: "rw"
          hwaccess: "hro"
          resval: 0
          fields: [
              {
                  bits: "0:0"
                  enum: [
                      { value: "0", name: "register", desc: "Connects the Pad to the internal configuration register."}
                      { value: "1", name: "port_usart0_uart_rts", desc: "Connect port uart_rts from port group usart0 to this pad." }
                  ]
              }
          ]
      }

      {
          name: A_31_CFG
          desc: '''
            Pad signal configuration.
          '''
          swaccess: "rw"
          fields: [
            {
                bits: "0"
                name: chip2pad
                desc: '''
                     The signal that connects to the pads TX driver
                '''
                swaccess: "rw"
                hwaccess: "hro"
                resval: "0"
            },
            {
                bits: "2:1"
                name: drv
                desc: '''
                     Driving strength
                '''
                swaccess: "rw"
                hwaccess: "hro"
                resval: "0"
            },
            {
                bits: "3"
                name: oen
                desc: '''
                     Output enable signal, active low
                '''
                swaccess: "rw"
                hwaccess: "hro"
                resval: "1"
            },
            {
                bits: "4"
                name: puen
                desc: '''
                     Pull-Up enable signal, active low
                '''
                swaccess: "rw"
                hwaccess: "hro"
                resval: "1"
            },
            {
                bits: "5"
                name: slw
                desc: '''
                     
                '''
                swaccess: "rw"
                hwaccess: "hro"
                resval: "0"
            },
            {
                bits: "6"
                name: smt
                desc: '''
                     Schmit trigger enable
                '''
                swaccess: "rw"
                hwaccess: "hro"
                resval: "0"
            },
          ]
      }

       {
          name: A_31_MUX_SEL
          desc: '''
              Pad signal port multiplex selection for pad a_31. The programmed value defines which port
              is connected to the pad.
          '''
          swaccess: "rw"
          hwaccess: "hro"
          resval: 0
          fields: [
              {
                  bits: "0:0"
                  enum: [
                      { value: "0", name: "register", desc: "Connects the Pad to the internal configuration register."}
                      { value: "1", name: "port_usart0_uart_cts", desc: "Connect port uart_cts from port group usart0 to this pad." }
                  ]
              }
          ]
      }

      {
          name: A_32_CFG
          desc: '''
            Pad signal configuration.
          '''
          swaccess: "rw"
          fields: [
            {
                bits: "0"
                name: chip2pad
                desc: '''
                     The signal that connects to the pads TX driver
                '''
                swaccess: "rw"
                hwaccess: "hro"
                resval: "0"
            },
            {
                bits: "2:1"
                name: drv
                desc: '''
                     Driving strength
                '''
                swaccess: "rw"
                hwaccess: "hro"
                resval: "0"
            },
            {
                bits: "3"
                name: oen
                desc: '''
                     Output enable signal, active low
                '''
                swaccess: "rw"
                hwaccess: "hro"
                resval: "1"
            },
            {
                bits: "4"
                name: puen
                desc: '''
                     Pull-Up enable signal, active low
                '''
                swaccess: "rw"
                hwaccess: "hro"
                resval: "1"
            },
            {
                bits: "5"
                name: slw
                desc: '''
                     
                '''
                swaccess: "rw"
                hwaccess: "hro"
                resval: "0"
            },
            {
                bits: "6"
                name: smt
                desc: '''
                     Schmit trigger enable
                '''
                swaccess: "rw"
                hwaccess: "hro"
                resval: "0"
            },
          ]
      }

       {
          name: A_32_MUX_SEL
          desc: '''
              Pad signal port multiplex selection for pad a_32. The programmed value defines which port
              is connected to the pad.
          '''
          swaccess: "rw"
          hwaccess: "hro"
          resval: 0
          fields: [
              {
                  bits: "0:0"
                  enum: [
                      { value: "0", name: "register", desc: "Connects the Pad to the internal configuration register."}
                      { value: "1", name: "port_spi4_spi_sck", desc: "Connect port spi_sck from port group spi4 to this pad." }
                  ]
              }
          ]
      }

      {
          name: A_33_CFG
          desc: '''
            Pad signal configuration.
          '''
          swaccess: "rw"
          fields: [
            {
                bits: "0"
                name: chip2pad
                desc: '''
                     The signal that connects to the pads TX driver
                '''
                swaccess: "rw"
                hwaccess: "hro"
                resval: "0"
            },
            {
                bits: "2:1"
                name: drv
                desc: '''
                     Driving strength
                '''
                swaccess: "rw"
                hwaccess: "hro"
                resval: "0"
            },
            {
                bits: "3"
                name: oen
                desc: '''
                     Output enable signal, active low
                '''
                swaccess: "rw"
                hwaccess: "hro"
                resval: "1"
            },
            {
                bits: "4"
                name: puen
                desc: '''
                     Pull-Up enable signal, active low
                '''
                swaccess: "rw"
                hwaccess: "hro"
                resval: "1"
            },
            {
                bits: "5"
                name: slw
                desc: '''
                     
                '''
                swaccess: "rw"
                hwaccess: "hro"
                resval: "0"
            },
            {
                bits: "6"
                name: smt
                desc: '''
                     Schmit trigger enable
                '''
                swaccess: "rw"
                hwaccess: "hro"
                resval: "0"
            },
          ]
      }

       {
          name: A_33_MUX_SEL
          desc: '''
              Pad signal port multiplex selection for pad a_33. The programmed value defines which port
              is connected to the pad.
          '''
          swaccess: "rw"
          hwaccess: "hro"
          resval: 0
          fields: [
              {
                  bits: "0:0"
                  enum: [
                      { value: "0", name: "register", desc: "Connects the Pad to the internal configuration register."}
                      { value: "1", name: "port_spi4_spi_cs0", desc: "Connect port spi_cs0 from port group spi4 to this pad." }
                  ]
              }
          ]
      }

      {
          name: A_34_CFG
          desc: '''
            Pad signal configuration.
          '''
          swaccess: "rw"
          fields: [
            {
                bits: "0"
                name: chip2pad
                desc: '''
                     The signal that connects to the pads TX driver
                '''
                swaccess: "rw"
                hwaccess: "hro"
                resval: "0"
            },
            {
                bits: "2:1"
                name: drv
                desc: '''
                     Driving strength
                '''
                swaccess: "rw"
                hwaccess: "hro"
                resval: "0"
            },
            {
                bits: "3"
                name: oen
                desc: '''
                     Output enable signal, active low
                '''
                swaccess: "rw"
                hwaccess: "hro"
                resval: "1"
            },
            {
                bits: "4"
                name: puen
                desc: '''
                     Pull-Up enable signal, active low
                '''
                swaccess: "rw"
                hwaccess: "hro"
                resval: "1"
            },
            {
                bits: "5"
                name: slw
                desc: '''
                     
                '''
                swaccess: "rw"
                hwaccess: "hro"
                resval: "0"
            },
            {
                bits: "6"
                name: smt
                desc: '''
                     Schmit trigger enable
                '''
                swaccess: "rw"
                hwaccess: "hro"
                resval: "0"
            },
          ]
      }

       {
          name: A_34_MUX_SEL
          desc: '''
              Pad signal port multiplex selection for pad a_34. The programmed value defines which port
              is connected to the pad.
          '''
          swaccess: "rw"
          hwaccess: "hro"
          resval: 0
          fields: [
              {
                  bits: "0:0"
                  enum: [
                      { value: "0", name: "register", desc: "Connects the Pad to the internal configuration register."}
                      { value: "1", name: "port_spi4_spi_miso", desc: "Connect port spi_miso from port group spi4 to this pad." }
                  ]
              }
          ]
      }

      {
          name: A_35_CFG
          desc: '''
            Pad signal configuration.
          '''
          swaccess: "rw"
          fields: [
            {
                bits: "0"
                name: chip2pad
                desc: '''
                     The signal that connects to the pads TX driver
                '''
                swaccess: "rw"
                hwaccess: "hro"
                resval: "0"
            },
            {
                bits: "2:1"
                name: drv
                desc: '''
                     Driving strength
                '''
                swaccess: "rw"
                hwaccess: "hro"
                resval: "0"
            },
            {
                bits: "3"
                name: oen
                desc: '''
                     Output enable signal, active low
                '''
                swaccess: "rw"
                hwaccess: "hro"
                resval: "1"
            },
            {
                bits: "4"
                name: puen
                desc: '''
                     Pull-Up enable signal, active low
                '''
                swaccess: "rw"
                hwaccess: "hro"
                resval: "1"
            },
            {
                bits: "5"
                name: slw
                desc: '''
                     
                '''
                swaccess: "rw"
                hwaccess: "hro"
                resval: "0"
            },
            {
                bits: "6"
                name: smt
                desc: '''
                     Schmit trigger enable
                '''
                swaccess: "rw"
                hwaccess: "hro"
                resval: "0"
            },
          ]
      }

       {
          name: A_35_MUX_SEL
          desc: '''
              Pad signal port multiplex selection for pad a_35. The programmed value defines which port
              is connected to the pad.
          '''
          swaccess: "rw"
          hwaccess: "hro"
          resval: 0
          fields: [
              {
                  bits: "0:0"
                  enum: [
                      { value: "0", name: "register", desc: "Connects the Pad to the internal configuration register."}
                      { value: "1", name: "port_spi4_spi_mosi", desc: "Connect port spi_mosi from port group spi4 to this pad." }
                  ]
              }
          ]
      }

      {
          name: A_36_CFG
          desc: '''
            Pad signal configuration.
          '''
          swaccess: "rw"
          fields: [
            {
                bits: "0"
                name: chip2pad
                desc: '''
                     The signal that connects to the pads TX driver
                '''
                swaccess: "rw"
                hwaccess: "hro"
                resval: "0"
            },
            {
                bits: "2:1"
                name: drv
                desc: '''
                     Driving strength
                '''
                swaccess: "rw"
                hwaccess: "hro"
                resval: "0"
            },
            {
                bits: "3"
                name: oen
                desc: '''
                     Output enable signal, active low
                '''
                swaccess: "rw"
                hwaccess: "hro"
                resval: "1"
            },
            {
                bits: "4"
                name: puen
                desc: '''
                     Pull-Up enable signal, active low
                '''
                swaccess: "rw"
                hwaccess: "hro"
                resval: "1"
            },
            {
                bits: "5"
                name: slw
                desc: '''
                     
                '''
                swaccess: "rw"
                hwaccess: "hro"
                resval: "0"
            },
            {
                bits: "6"
                name: smt
                desc: '''
                     Schmit trigger enable
                '''
                swaccess: "rw"
                hwaccess: "hro"
                resval: "0"
            },
          ]
      }

       {
          name: A_36_MUX_SEL
          desc: '''
              Pad signal port multiplex selection for pad a_36. The programmed value defines which port
              is connected to the pad.
          '''
          swaccess: "rw"
          hwaccess: "hro"
          resval: 0
          fields: [
              {
                  bits: "0:0"
                  enum: [
                      { value: "0", name: "register", desc: "Connects the Pad to the internal configuration register."}
                      { value: "1", name: "port_i2c2_i2c_scl", desc: "Connect port i2c_scl from port group i2c2 to this pad." }
                  ]
              }
          ]
      }

      {
          name: A_37_CFG
          desc: '''
            Pad signal configuration.
          '''
          swaccess: "rw"
          fields: [
            {
                bits: "0"
                name: chip2pad
                desc: '''
                     The signal that connects to the pads TX driver
                '''
                swaccess: "rw"
                hwaccess: "hro"
                resval: "0"
            },
            {
                bits: "2:1"
                name: drv
                desc: '''
                     Driving strength
                '''
                swaccess: "rw"
                hwaccess: "hro"
                resval: "0"
            },
            {
                bits: "3"
                name: oen
                desc: '''
                     Output enable signal, active low
                '''
                swaccess: "rw"
                hwaccess: "hro"
                resval: "1"
            },
            {
                bits: "4"
                name: puen
                desc: '''
                     Pull-Up enable signal, active low
                '''
                swaccess: "rw"
                hwaccess: "hro"
                resval: "1"
            },
            {
                bits: "5"
                name: slw
                desc: '''
                     
                '''
                swaccess: "rw"
                hwaccess: "hro"
                resval: "0"
            },
            {
                bits: "6"
                name: smt
                desc: '''
                     Schmit trigger enable
                '''
                swaccess: "rw"
                hwaccess: "hro"
                resval: "0"
            },
          ]
      }

       {
          name: A_37_MUX_SEL
          desc: '''
              Pad signal port multiplex selection for pad a_37. The programmed value defines which port
              is connected to the pad.
          '''
          swaccess: "rw"
          hwaccess: "hro"
          resval: 0
          fields: [
              {
                  bits: "0:0"
                  enum: [
                      { value: "0", name: "register", desc: "Connects the Pad to the internal configuration register."}
                      { value: "1", name: "port_i2c2_i2c_sda", desc: "Connect port i2c_sda from port group i2c2 to this pad." }
                  ]
              }
          ]
      }

      {
          name: A_38_CFG
          desc: '''
            Pad signal configuration.
          '''
          swaccess: "rw"
          fields: [
            {
                bits: "0"
                name: chip2pad
                desc: '''
                     The signal that connects to the pads TX driver
                '''
                swaccess: "rw"
                hwaccess: "hro"
                resval: "0"
            },
            {
                bits: "2:1"
                name: drv
                desc: '''
                     Driving strength
                '''
                swaccess: "rw"
                hwaccess: "hro"
                resval: "0"
            },
            {
                bits: "3"
                name: oen
                desc: '''
                     Output enable signal, active low
                '''
                swaccess: "rw"
                hwaccess: "hro"
                resval: "1"
            },
            {
                bits: "4"
                name: puen
                desc: '''
                     Pull-Up enable signal, active low
                '''
                swaccess: "rw"
                hwaccess: "hro"
                resval: "1"
            },
            {
                bits: "5"
                name: slw
                desc: '''
                     
                '''
                swaccess: "rw"
                hwaccess: "hro"
                resval: "0"
            },
            {
                bits: "6"
                name: smt
                desc: '''
                     Schmit trigger enable
                '''
                swaccess: "rw"
                hwaccess: "hro"
                resval: "0"
            },
          ]
      }

       {
          name: A_38_MUX_SEL
          desc: '''
              Pad signal port multiplex selection for pad a_38. The programmed value defines which port
              is connected to the pad.
          '''
          swaccess: "rw"
          hwaccess: "hro"
          resval: 0
          fields: [
              {
                  bits: "0:0"
                  enum: [
                      { value: "0", name: "register", desc: "Connects the Pad to the internal configuration register."}
                      { value: "1", name: "port_pwm0_pwm0", desc: "Connect port pwm0 from port group pwm0 to this pad." }
                  ]
              }
          ]
      }

      {
          name: A_39_CFG
          desc: '''
            Pad signal configuration.
          '''
          swaccess: "rw"
          fields: [
            {
                bits: "0"
                name: chip2pad
                desc: '''
                     The signal that connects to the pads TX driver
                '''
                swaccess: "rw"
                hwaccess: "hro"
                resval: "0"
            },
            {
                bits: "2:1"
                name: drv
                desc: '''
                     Driving strength
                '''
                swaccess: "rw"
                hwaccess: "hro"
                resval: "0"
            },
            {
                bits: "3"
                name: oen
                desc: '''
                     Output enable signal, active low
                '''
                swaccess: "rw"
                hwaccess: "hro"
                resval: "1"
            },
            {
                bits: "4"
                name: puen
                desc: '''
                     Pull-Up enable signal, active low
                '''
                swaccess: "rw"
                hwaccess: "hro"
                resval: "1"
            },
            {
                bits: "5"
                name: slw
                desc: '''
                     
                '''
                swaccess: "rw"
                hwaccess: "hro"
                resval: "0"
            },
            {
                bits: "6"
                name: smt
                desc: '''
                     Schmit trigger enable
                '''
                swaccess: "rw"
                hwaccess: "hro"
                resval: "0"
            },
          ]
      }

       {
          name: A_39_MUX_SEL
          desc: '''
              Pad signal port multiplex selection for pad a_39. The programmed value defines which port
              is connected to the pad.
          '''
          swaccess: "rw"
          hwaccess: "hro"
          resval: 0
          fields: [
              {
                  bits: "0:0"
                  enum: [
                      { value: "0", name: "register", desc: "Connects the Pad to the internal configuration register."}
                      { value: "1", name: "port_pwm0_pwm1", desc: "Connect port pwm1 from port group pwm0 to this pad." }
                  ]
              }
          ]
      }

      {
          name: A_40_CFG
          desc: '''
            Pad signal configuration.
          '''
          swaccess: "rw"
          fields: [
            {
                bits: "0"
                name: chip2pad
                desc: '''
                     The signal that connects to the pads TX driver
                '''
                swaccess: "rw"
                hwaccess: "hro"
                resval: "0"
            },
            {
                bits: "2:1"
                name: drv
                desc: '''
                     Driving strength
                '''
                swaccess: "rw"
                hwaccess: "hro"
                resval: "0"
            },
            {
                bits: "3"
                name: oen
                desc: '''
                     Output enable signal, active low
                '''
                swaccess: "rw"
                hwaccess: "hro"
                resval: "1"
            },
            {
                bits: "4"
                name: puen
                desc: '''
                     Pull-Up enable signal, active low
                '''
                swaccess: "rw"
                hwaccess: "hro"
                resval: "1"
            },
            {
                bits: "5"
                name: slw
                desc: '''
                     
                '''
                swaccess: "rw"
                hwaccess: "hro"
                resval: "0"
            },
            {
                bits: "6"
                name: smt
                desc: '''
                     Schmit trigger enable
                '''
                swaccess: "rw"
                hwaccess: "hro"
                resval: "0"
            },
          ]
      }

       {
          name: A_40_MUX_SEL
          desc: '''
              Pad signal port multiplex selection for pad a_40. The programmed value defines which port
              is connected to the pad.
          '''
          swaccess: "rw"
          hwaccess: "hro"
          resval: 0
          fields: [
              {
                  bits: "0:0"
                  enum: [
                      { value: "0", name: "register", desc: "Connects the Pad to the internal configuration register."}
                      { value: "1", name: "port_pwm0_pwm2", desc: "Connect port pwm2 from port group pwm0 to this pad." }
                  ]
              }
          ]
      }

      {
          name: A_41_CFG
          desc: '''
            Pad signal configuration.
          '''
          swaccess: "rw"
          fields: [
            {
                bits: "0"
                name: chip2pad
                desc: '''
                     The signal that connects to the pads TX driver
                '''
                swaccess: "rw"
                hwaccess: "hro"
                resval: "0"
            },
            {
                bits: "2:1"
                name: drv
                desc: '''
                     Driving strength
                '''
                swaccess: "rw"
                hwaccess: "hro"
                resval: "0"
            },
            {
                bits: "3"
                name: oen
                desc: '''
                     Output enable signal, active low
                '''
                swaccess: "rw"
                hwaccess: "hro"
                resval: "1"
            },
            {
                bits: "4"
                name: puen
                desc: '''
                     Pull-Up enable signal, active low
                '''
                swaccess: "rw"
                hwaccess: "hro"
                resval: "1"
            },
            {
                bits: "5"
                name: slw
                desc: '''
                     
                '''
                swaccess: "rw"
                hwaccess: "hro"
                resval: "0"
            },
            {
                bits: "6"
                name: smt
                desc: '''
                     Schmit trigger enable
                '''
                swaccess: "rw"
                hwaccess: "hro"
                resval: "0"
            },
          ]
      }

       {
          name: A_41_MUX_SEL
          desc: '''
              Pad signal port multiplex selection for pad a_41. The programmed value defines which port
              is connected to the pad.
          '''
          swaccess: "rw"
          hwaccess: "hro"
          resval: 0
          fields: [
              {
                  bits: "0:0"
                  enum: [
                      { value: "0", name: "register", desc: "Connects the Pad to the internal configuration register."}
                      { value: "1", name: "port_pwm0_pwm3", desc: "Connect port pwm3 from port group pwm0 to this pad." }
                  ]
              }
          ]
      }

      {
          name: A_42_CFG
          desc: '''
            Pad signal configuration.
          '''
          swaccess: "rw"
          fields: [
            {
                bits: "0"
                name: chip2pad
                desc: '''
                     The signal that connects to the pads TX driver
                '''
                swaccess: "rw"
                hwaccess: "hro"
                resval: "0"
            },
            {
                bits: "2:1"
                name: drv
                desc: '''
                     Driving strength
                '''
                swaccess: "rw"
                hwaccess: "hro"
                resval: "0"
            },
            {
                bits: "3"
                name: oen
                desc: '''
                     Output enable signal, active low
                '''
                swaccess: "rw"
                hwaccess: "hro"
                resval: "1"
            },
            {
                bits: "4"
                name: puen
                desc: '''
                     Pull-Up enable signal, active low
                '''
                swaccess: "rw"
                hwaccess: "hro"
                resval: "1"
            },
            {
                bits: "5"
                name: slw
                desc: '''
                     
                '''
                swaccess: "rw"
                hwaccess: "hro"
                resval: "0"
            },
            {
                bits: "6"
                name: smt
                desc: '''
                     Schmit trigger enable
                '''
                swaccess: "rw"
                hwaccess: "hro"
                resval: "0"
            },
          ]
      }

       {
          name: A_42_MUX_SEL
          desc: '''
              Pad signal port multiplex selection for pad a_42. The programmed value defines which port
              is connected to the pad.
          '''
          swaccess: "rw"
          hwaccess: "hro"
          resval: 0
          fields: [
              {
                  bits: "1:0"
                  enum: [
                      { value: "0", name: "register", desc: "Connects the Pad to the internal configuration register."}
                      { value: "1", name: "port_cam0_cam_pclk", desc: "Connect port cam_pclk from port group cam0 to this pad." }
                      { value: "2", name: "port_i2c3_i2c_scl", desc: "Connect port i2c_scl from port group i2c3 to this pad." }
                  ]
              }
          ]
      }

      {
          name: A_43_CFG
          desc: '''
            Pad signal configuration.
          '''
          swaccess: "rw"
          fields: [
            {
                bits: "0"
                name: chip2pad
                desc: '''
                     The signal that connects to the pads TX driver
                '''
                swaccess: "rw"
                hwaccess: "hro"
                resval: "0"
            },
            {
                bits: "2:1"
                name: drv
                desc: '''
                     Driving strength
                '''
                swaccess: "rw"
                hwaccess: "hro"
                resval: "0"
            },
            {
                bits: "3"
                name: oen
                desc: '''
                     Output enable signal, active low
                '''
                swaccess: "rw"
                hwaccess: "hro"
                resval: "1"
            },
            {
                bits: "4"
                name: puen
                desc: '''
                     Pull-Up enable signal, active low
                '''
                swaccess: "rw"
                hwaccess: "hro"
                resval: "1"
            },
            {
                bits: "5"
                name: slw
                desc: '''
                     
                '''
                swaccess: "rw"
                hwaccess: "hro"
                resval: "0"
            },
            {
                bits: "6"
                name: smt
                desc: '''
                     Schmit trigger enable
                '''
                swaccess: "rw"
                hwaccess: "hro"
                resval: "0"
            },
          ]
      }

       {
          name: A_43_MUX_SEL
          desc: '''
              Pad signal port multiplex selection for pad a_43. The programmed value defines which port
              is connected to the pad.
          '''
          swaccess: "rw"
          hwaccess: "hro"
          resval: 0
          fields: [
              {
                  bits: "1:0"
                  enum: [
                      { value: "0", name: "register", desc: "Connects the Pad to the internal configuration register."}
                      { value: "1", name: "port_cam0_cam_vsync", desc: "Connect port cam_vsync from port group cam0 to this pad." }
                      { value: "2", name: "port_i2c3_i2c_sda", desc: "Connect port i2c_sda from port group i2c3 to this pad." }
                  ]
              }
          ]
      }

      {
          name: A_44_CFG
          desc: '''
            Pad signal configuration.
          '''
          swaccess: "rw"
          fields: [
            {
                bits: "0"
                name: chip2pad
                desc: '''
                     The signal that connects to the pads TX driver
                '''
                swaccess: "rw"
                hwaccess: "hro"
                resval: "0"
            },
            {
                bits: "2:1"
                name: drv
                desc: '''
                     Driving strength
                '''
                swaccess: "rw"
                hwaccess: "hro"
                resval: "0"
            },
            {
                bits: "3"
                name: oen
                desc: '''
                     Output enable signal, active low
                '''
                swaccess: "rw"
                hwaccess: "hro"
                resval: "1"
            },
            {
                bits: "4"
                name: puen
                desc: '''
                     Pull-Up enable signal, active low
                '''
                swaccess: "rw"
                hwaccess: "hro"
                resval: "1"
            },
            {
                bits: "5"
                name: slw
                desc: '''
                     
                '''
                swaccess: "rw"
                hwaccess: "hro"
                resval: "0"
            },
            {
                bits: "6"
                name: smt
                desc: '''
                     Schmit trigger enable
                '''
                swaccess: "rw"
                hwaccess: "hro"
                resval: "0"
            },
          ]
      }

       {
          name: A_44_MUX_SEL
          desc: '''
              Pad signal port multiplex selection for pad a_44. The programmed value defines which port
              is connected to the pad.
          '''
          swaccess: "rw"
          hwaccess: "hro"
          resval: 0
          fields: [
              {
                  bits: "1:0"
                  enum: [
                      { value: "0", name: "register", desc: "Connects the Pad to the internal configuration register."}
                      { value: "1", name: "port_cam0_cam_data0_i", desc: "Connect port cam_data0_i from port group cam0 to this pad." }
                      { value: "2", name: "port_spi5_spi_sck", desc: "Connect port spi_sck from port group spi5 to this pad." }
                  ]
              }
          ]
      }

      {
          name: A_45_CFG
          desc: '''
            Pad signal configuration.
          '''
          swaccess: "rw"
          fields: [
            {
                bits: "0"
                name: chip2pad
                desc: '''
                     The signal that connects to the pads TX driver
                '''
                swaccess: "rw"
                hwaccess: "hro"
                resval: "0"
            },
            {
                bits: "2:1"
                name: drv
                desc: '''
                     Driving strength
                '''
                swaccess: "rw"
                hwaccess: "hro"
                resval: "0"
            },
            {
                bits: "3"
                name: oen
                desc: '''
                     Output enable signal, active low
                '''
                swaccess: "rw"
                hwaccess: "hro"
                resval: "1"
            },
            {
                bits: "4"
                name: puen
                desc: '''
                     Pull-Up enable signal, active low
                '''
                swaccess: "rw"
                hwaccess: "hro"
                resval: "1"
            },
            {
                bits: "5"
                name: slw
                desc: '''
                     
                '''
                swaccess: "rw"
                hwaccess: "hro"
                resval: "0"
            },
            {
                bits: "6"
                name: smt
                desc: '''
                     Schmit trigger enable
                '''
                swaccess: "rw"
                hwaccess: "hro"
                resval: "0"
            },
          ]
      }

       {
          name: A_45_MUX_SEL
          desc: '''
              Pad signal port multiplex selection for pad a_45. The programmed value defines which port
              is connected to the pad.
          '''
          swaccess: "rw"
          hwaccess: "hro"
          resval: 0
          fields: [
              {
                  bits: "1:0"
                  enum: [
                      { value: "0", name: "register", desc: "Connects the Pad to the internal configuration register."}
                      { value: "1", name: "port_cam0_cam_data1_i", desc: "Connect port cam_data1_i from port group cam0 to this pad." }
                      { value: "2", name: "port_spi5_spi_cs0", desc: "Connect port spi_cs0 from port group spi5 to this pad." }
                  ]
              }
          ]
      }

      {
          name: A_46_CFG
          desc: '''
            Pad signal configuration.
          '''
          swaccess: "rw"
          fields: [
            {
                bits: "0"
                name: chip2pad
                desc: '''
                     The signal that connects to the pads TX driver
                '''
                swaccess: "rw"
                hwaccess: "hro"
                resval: "0"
            },
            {
                bits: "2:1"
                name: drv
                desc: '''
                     Driving strength
                '''
                swaccess: "rw"
                hwaccess: "hro"
                resval: "0"
            },
            {
                bits: "3"
                name: oen
                desc: '''
                     Output enable signal, active low
                '''
                swaccess: "rw"
                hwaccess: "hro"
                resval: "1"
            },
            {
                bits: "4"
                name: puen
                desc: '''
                     Pull-Up enable signal, active low
                '''
                swaccess: "rw"
                hwaccess: "hro"
                resval: "1"
            },
            {
                bits: "5"
                name: slw
                desc: '''
                     
                '''
                swaccess: "rw"
                hwaccess: "hro"
                resval: "0"
            },
            {
                bits: "6"
                name: smt
                desc: '''
                     Schmit trigger enable
                '''
                swaccess: "rw"
                hwaccess: "hro"
                resval: "0"
            },
          ]
      }

       {
          name: A_46_MUX_SEL
          desc: '''
              Pad signal port multiplex selection for pad a_46. The programmed value defines which port
              is connected to the pad.
          '''
          swaccess: "rw"
          hwaccess: "hro"
          resval: 0
          fields: [
              {
                  bits: "1:0"
                  enum: [
                      { value: "0", name: "register", desc: "Connects the Pad to the internal configuration register."}
                      { value: "1", name: "port_cam0_cam_data2_i", desc: "Connect port cam_data2_i from port group cam0 to this pad." }
                      { value: "2", name: "port_spi5_spi_miso", desc: "Connect port spi_miso from port group spi5 to this pad." }
                  ]
              }
          ]
      }

      {
          name: A_47_CFG
          desc: '''
            Pad signal configuration.
          '''
          swaccess: "rw"
          fields: [
            {
                bits: "0"
                name: chip2pad
                desc: '''
                     The signal that connects to the pads TX driver
                '''
                swaccess: "rw"
                hwaccess: "hro"
                resval: "0"
            },
            {
                bits: "2:1"
                name: drv
                desc: '''
                     Driving strength
                '''
                swaccess: "rw"
                hwaccess: "hro"
                resval: "0"
            },
            {
                bits: "3"
                name: oen
                desc: '''
                     Output enable signal, active low
                '''
                swaccess: "rw"
                hwaccess: "hro"
                resval: "1"
            },
            {
                bits: "4"
                name: puen
                desc: '''
                     Pull-Up enable signal, active low
                '''
                swaccess: "rw"
                hwaccess: "hro"
                resval: "1"
            },
            {
                bits: "5"
                name: slw
                desc: '''
                     
                '''
                swaccess: "rw"
                hwaccess: "hro"
                resval: "0"
            },
            {
                bits: "6"
                name: smt
                desc: '''
                     Schmit trigger enable
                '''
                swaccess: "rw"
                hwaccess: "hro"
                resval: "0"
            },
          ]
      }

       {
          name: A_47_MUX_SEL
          desc: '''
              Pad signal port multiplex selection for pad a_47. The programmed value defines which port
              is connected to the pad.
          '''
          swaccess: "rw"
          hwaccess: "hro"
          resval: 0
          fields: [
              {
                  bits: "1:0"
                  enum: [
                      { value: "0", name: "register", desc: "Connects the Pad to the internal configuration register."}
                      { value: "1", name: "port_cam0_cam_data3_i", desc: "Connect port cam_data3_i from port group cam0 to this pad." }
                      { value: "2", name: "port_spi5_spi_mosi", desc: "Connect port spi_mosi from port group spi5 to this pad." }
                  ]
              }
          ]
      }

      {
          name: A_48_CFG
          desc: '''
            Pad signal configuration.
          '''
          swaccess: "rw"
          fields: [
            {
                bits: "0"
                name: chip2pad
                desc: '''
                     The signal that connects to the pads TX driver
                '''
                swaccess: "rw"
                hwaccess: "hro"
                resval: "0"
            },
            {
                bits: "2:1"
                name: drv
                desc: '''
                     Driving strength
                '''
                swaccess: "rw"
                hwaccess: "hro"
                resval: "0"
            },
            {
                bits: "3"
                name: oen
                desc: '''
                     Output enable signal, active low
                '''
                swaccess: "rw"
                hwaccess: "hro"
                resval: "1"
            },
            {
                bits: "4"
                name: puen
                desc: '''
                     Pull-Up enable signal, active low
                '''
                swaccess: "rw"
                hwaccess: "hro"
                resval: "1"
            },
            {
                bits: "5"
                name: slw
                desc: '''
                     
                '''
                swaccess: "rw"
                hwaccess: "hro"
                resval: "0"
            },
            {
                bits: "6"
                name: smt
                desc: '''
                     Schmit trigger enable
                '''
                swaccess: "rw"
                hwaccess: "hro"
                resval: "0"
            },
          ]
      }

       {
          name: A_48_MUX_SEL
          desc: '''
              Pad signal port multiplex selection for pad a_48. The programmed value defines which port
              is connected to the pad.
          '''
          swaccess: "rw"
          hwaccess: "hro"
          resval: 0
          fields: [
              {
                  bits: "1:0"
                  enum: [
                      { value: "0", name: "register", desc: "Connects the Pad to the internal configuration register."}
                      { value: "1", name: "port_cam0_cam_data5_i", desc: "Connect port cam_data5_i from port group cam0 to this pad." }
                      { value: "2", name: "port_spi6_spi_sck", desc: "Connect port spi_sck from port group spi6 to this pad." }
                  ]
              }
          ]
      }

      {
          name: A_49_CFG
          desc: '''
            Pad signal configuration.
          '''
          swaccess: "rw"
          fields: [
            {
                bits: "0"
                name: chip2pad
                desc: '''
                     The signal that connects to the pads TX driver
                '''
                swaccess: "rw"
                hwaccess: "hro"
                resval: "0"
            },
            {
                bits: "2:1"
                name: drv
                desc: '''
                     Driving strength
                '''
                swaccess: "rw"
                hwaccess: "hro"
                resval: "0"
            },
            {
                bits: "3"
                name: oen
                desc: '''
                     Output enable signal, active low
                '''
                swaccess: "rw"
                hwaccess: "hro"
                resval: "1"
            },
            {
                bits: "4"
                name: puen
                desc: '''
                     Pull-Up enable signal, active low
                '''
                swaccess: "rw"
                hwaccess: "hro"
                resval: "1"
            },
            {
                bits: "5"
                name: slw
                desc: '''
                     
                '''
                swaccess: "rw"
                hwaccess: "hro"
                resval: "0"
            },
            {
                bits: "6"
                name: smt
                desc: '''
                     Schmit trigger enable
                '''
                swaccess: "rw"
                hwaccess: "hro"
                resval: "0"
            },
          ]
      }

       {
          name: A_49_MUX_SEL
          desc: '''
              Pad signal port multiplex selection for pad a_49. The programmed value defines which port
              is connected to the pad.
          '''
          swaccess: "rw"
          hwaccess: "hro"
          resval: 0
          fields: [
              {
                  bits: "1:0"
                  enum: [
                      { value: "0", name: "register", desc: "Connects the Pad to the internal configuration register."}
                      { value: "1", name: "port_cam0_cam_data6_i", desc: "Connect port cam_data6_i from port group cam0 to this pad." }
                      { value: "2", name: "port_spi6_spi_cs0", desc: "Connect port spi_cs0 from port group spi6 to this pad." }
                  ]
              }
          ]
      }

      {
          name: A_50_CFG
          desc: '''
            Pad signal configuration.
          '''
          swaccess: "rw"
          fields: [
            {
                bits: "0"
                name: chip2pad
                desc: '''
                     The signal that connects to the pads TX driver
                '''
                swaccess: "rw"
                hwaccess: "hro"
                resval: "0"
            },
            {
                bits: "2:1"
                name: drv
                desc: '''
                     Driving strength
                '''
                swaccess: "rw"
                hwaccess: "hro"
                resval: "0"
            },
            {
                bits: "3"
                name: oen
                desc: '''
                     Output enable signal, active low
                '''
                swaccess: "rw"
                hwaccess: "hro"
                resval: "1"
            },
            {
                bits: "4"
                name: puen
                desc: '''
                     Pull-Up enable signal, active low
                '''
                swaccess: "rw"
                hwaccess: "hro"
                resval: "1"
            },
            {
                bits: "5"
                name: slw
                desc: '''
                     
                '''
                swaccess: "rw"
                hwaccess: "hro"
                resval: "0"
            },
            {
                bits: "6"
                name: smt
                desc: '''
                     Schmit trigger enable
                '''
                swaccess: "rw"
                hwaccess: "hro"
                resval: "0"
            },
          ]
      }

       {
          name: A_50_MUX_SEL
          desc: '''
              Pad signal port multiplex selection for pad a_50. The programmed value defines which port
              is connected to the pad.
          '''
          swaccess: "rw"
          hwaccess: "hro"
          resval: 0
          fields: [
              {
                  bits: "1:0"
                  enum: [
                      { value: "0", name: "register", desc: "Connects the Pad to the internal configuration register."}
                      { value: "1", name: "port_cam0_cam_data7_i", desc: "Connect port cam_data7_i from port group cam0 to this pad." }
                      { value: "2", name: "port_spi6_spi_miso", desc: "Connect port spi_miso from port group spi6 to this pad." }
                  ]
              }
          ]
      }

      {
          name: A_51_CFG
          desc: '''
            Pad signal configuration.
          '''
          swaccess: "rw"
          fields: [
            {
                bits: "0"
                name: chip2pad
                desc: '''
                     The signal that connects to the pads TX driver
                '''
                swaccess: "rw"
                hwaccess: "hro"
                resval: "0"
            },
            {
                bits: "2:1"
                name: drv
                desc: '''
                     Driving strength
                '''
                swaccess: "rw"
                hwaccess: "hro"
                resval: "0"
            },
            {
                bits: "3"
                name: oen
                desc: '''
                     Output enable signal, active low
                '''
                swaccess: "rw"
                hwaccess: "hro"
                resval: "1"
            },
            {
                bits: "4"
                name: puen
                desc: '''
                     Pull-Up enable signal, active low
                '''
                swaccess: "rw"
                hwaccess: "hro"
                resval: "1"
            },
            {
                bits: "5"
                name: slw
                desc: '''
                     
                '''
                swaccess: "rw"
                hwaccess: "hro"
                resval: "0"
            },
            {
                bits: "6"
                name: smt
                desc: '''
                     Schmit trigger enable
                '''
                swaccess: "rw"
                hwaccess: "hro"
                resval: "0"
            },
          ]
      }

       {
          name: A_51_MUX_SEL
          desc: '''
              Pad signal port multiplex selection for pad a_51. The programmed value defines which port
              is connected to the pad.
          '''
          swaccess: "rw"
          hwaccess: "hro"
          resval: 0
          fields: [
              {
                  bits: "1:0"
                  enum: [
                      { value: "0", name: "register", desc: "Connects the Pad to the internal configuration register."}
                      { value: "1", name: "port_cam1_cam_pclk", desc: "Connect port cam_pclk from port group cam1 to this pad." }
                      { value: "2", name: "port_spi6_spi_mosi", desc: "Connect port spi_mosi from port group spi6 to this pad." }
                  ]
              }
          ]
      }

      {
          name: A_52_CFG
          desc: '''
            Pad signal configuration.
          '''
          swaccess: "rw"
          fields: [
            {
                bits: "0"
                name: chip2pad
                desc: '''
                     The signal that connects to the pads TX driver
                '''
                swaccess: "rw"
                hwaccess: "hro"
                resval: "0"
            },
            {
                bits: "2:1"
                name: drv
                desc: '''
                     Driving strength
                '''
                swaccess: "rw"
                hwaccess: "hro"
                resval: "0"
            },
            {
                bits: "3"
                name: oen
                desc: '''
                     Output enable signal, active low
                '''
                swaccess: "rw"
                hwaccess: "hro"
                resval: "1"
            },
            {
                bits: "4"
                name: puen
                desc: '''
                     Pull-Up enable signal, active low
                '''
                swaccess: "rw"
                hwaccess: "hro"
                resval: "1"
            },
            {
                bits: "5"
                name: slw
                desc: '''
                     
                '''
                swaccess: "rw"
                hwaccess: "hro"
                resval: "0"
            },
            {
                bits: "6"
                name: smt
                desc: '''
                     Schmit trigger enable
                '''
                swaccess: "rw"
                hwaccess: "hro"
                resval: "0"
            },
          ]
      }

       {
          name: A_52_MUX_SEL
          desc: '''
              Pad signal port multiplex selection for pad a_52. The programmed value defines which port
              is connected to the pad.
          '''
          swaccess: "rw"
          hwaccess: "hro"
          resval: 0
          fields: [
              {
                  bits: "1:0"
                  enum: [
                      { value: "0", name: "register", desc: "Connects the Pad to the internal configuration register."}
                      { value: "1", name: "port_cam1_cam_hsync", desc: "Connect port cam_hsync from port group cam1 to this pad." }
                      { value: "2", name: "port_spi7_spi_sck", desc: "Connect port spi_sck from port group spi7 to this pad." }
                  ]
              }
          ]
      }

      {
          name: A_53_CFG
          desc: '''
            Pad signal configuration.
          '''
          swaccess: "rw"
          fields: [
            {
                bits: "0"
                name: chip2pad
                desc: '''
                     The signal that connects to the pads TX driver
                '''
                swaccess: "rw"
                hwaccess: "hro"
                resval: "0"
            },
            {
                bits: "2:1"
                name: drv
                desc: '''
                     Driving strength
                '''
                swaccess: "rw"
                hwaccess: "hro"
                resval: "0"
            },
            {
                bits: "3"
                name: oen
                desc: '''
                     Output enable signal, active low
                '''
                swaccess: "rw"
                hwaccess: "hro"
                resval: "1"
            },
            {
                bits: "4"
                name: puen
                desc: '''
                     Pull-Up enable signal, active low
                '''
                swaccess: "rw"
                hwaccess: "hro"
                resval: "1"
            },
            {
                bits: "5"
                name: slw
                desc: '''
                     
                '''
                swaccess: "rw"
                hwaccess: "hro"
                resval: "0"
            },
            {
                bits: "6"
                name: smt
                desc: '''
                     Schmit trigger enable
                '''
                swaccess: "rw"
                hwaccess: "hro"
                resval: "0"
            },
          ]
      }

       {
          name: A_53_MUX_SEL
          desc: '''
              Pad signal port multiplex selection for pad a_53. The programmed value defines which port
              is connected to the pad.
          '''
          swaccess: "rw"
          hwaccess: "hro"
          resval: 0
          fields: [
              {
                  bits: "1:0"
                  enum: [
                      { value: "0", name: "register", desc: "Connects the Pad to the internal configuration register."}
                      { value: "1", name: "port_cam1_cam_data0_i", desc: "Connect port cam_data0_i from port group cam1 to this pad." }
                      { value: "2", name: "port_spi7_spi_miso", desc: "Connect port spi_miso from port group spi7 to this pad." }
                  ]
              }
          ]
      }

      {
          name: A_54_CFG
          desc: '''
            Pad signal configuration.
          '''
          swaccess: "rw"
          fields: [
            {
                bits: "0"
                name: chip2pad
                desc: '''
                     The signal that connects to the pads TX driver
                '''
                swaccess: "rw"
                hwaccess: "hro"
                resval: "0"
            },
            {
                bits: "2:1"
                name: drv
                desc: '''
                     Driving strength
                '''
                swaccess: "rw"
                hwaccess: "hro"
                resval: "0"
            },
            {
                bits: "3"
                name: oen
                desc: '''
                     Output enable signal, active low
                '''
                swaccess: "rw"
                hwaccess: "hro"
                resval: "1"
            },
            {
                bits: "4"
                name: puen
                desc: '''
                     Pull-Up enable signal, active low
                '''
                swaccess: "rw"
                hwaccess: "hro"
                resval: "1"
            },
            {
                bits: "5"
                name: slw
                desc: '''
                     
                '''
                swaccess: "rw"
                hwaccess: "hro"
                resval: "0"
            },
            {
                bits: "6"
                name: smt
                desc: '''
                     Schmit trigger enable
                '''
                swaccess: "rw"
                hwaccess: "hro"
                resval: "0"
            },
          ]
      }

       {
          name: A_54_MUX_SEL
          desc: '''
              Pad signal port multiplex selection for pad a_54. The programmed value defines which port
              is connected to the pad.
          '''
          swaccess: "rw"
          hwaccess: "hro"
          resval: 0
          fields: [
              {
                  bits: "1:0"
                  enum: [
                      { value: "0", name: "register", desc: "Connects the Pad to the internal configuration register."}
                      { value: "1", name: "port_cam1_cam_data1_i", desc: "Connect port cam_data1_i from port group cam1 to this pad." }
                      { value: "2", name: "port_spi7_spi_mosi", desc: "Connect port spi_mosi from port group spi7 to this pad." }
                  ]
              }
          ]
      }

      {
          name: A_55_CFG
          desc: '''
            Pad signal configuration.
          '''
          swaccess: "rw"
          fields: [
            {
                bits: "0"
                name: chip2pad
                desc: '''
                     The signal that connects to the pads TX driver
                '''
                swaccess: "rw"
                hwaccess: "hro"
                resval: "0"
            },
            {
                bits: "2:1"
                name: drv
                desc: '''
                     Driving strength
                '''
                swaccess: "rw"
                hwaccess: "hro"
                resval: "0"
            },
            {
                bits: "3"
                name: oen
                desc: '''
                     Output enable signal, active low
                '''
                swaccess: "rw"
                hwaccess: "hro"
                resval: "1"
            },
            {
                bits: "4"
                name: puen
                desc: '''
                     Pull-Up enable signal, active low
                '''
                swaccess: "rw"
                hwaccess: "hro"
                resval: "1"
            },
            {
                bits: "5"
                name: slw
                desc: '''
                     
                '''
                swaccess: "rw"
                hwaccess: "hro"
                resval: "0"
            },
            {
                bits: "6"
                name: smt
                desc: '''
                     Schmit trigger enable
                '''
                swaccess: "rw"
                hwaccess: "hro"
                resval: "0"
            },
          ]
      }

       {
          name: A_55_MUX_SEL
          desc: '''
              Pad signal port multiplex selection for pad a_55. The programmed value defines which port
              is connected to the pad.
          '''
          swaccess: "rw"
          hwaccess: "hro"
          resval: 0
          fields: [
              {
                  bits: "1:0"
                  enum: [
                      { value: "0", name: "register", desc: "Connects the Pad to the internal configuration register."}
                      { value: "1", name: "port_cam1_cam_data5_i", desc: "Connect port cam_data5_i from port group cam1 to this pad." }
                      { value: "2", name: "port_spi7_spi_cs0", desc: "Connect port spi_cs0 from port group spi7 to this pad." }
                  ]
              }
          ]
      }

      {
          name: A_56_CFG
          desc: '''
            Pad signal configuration.
          '''
          swaccess: "rw"
          fields: [
            {
                bits: "0"
                name: chip2pad
                desc: '''
                     The signal that connects to the pads TX driver
                '''
                swaccess: "rw"
                hwaccess: "hro"
                resval: "0"
            },
            {
                bits: "2:1"
                name: drv
                desc: '''
                     Driving strength
                '''
                swaccess: "rw"
                hwaccess: "hro"
                resval: "0"
            },
            {
                bits: "3"
                name: oen
                desc: '''
                     Output enable signal, active low
                '''
                swaccess: "rw"
                hwaccess: "hro"
                resval: "1"
            },
            {
                bits: "4"
                name: puen
                desc: '''
                     Pull-Up enable signal, active low
                '''
                swaccess: "rw"
                hwaccess: "hro"
                resval: "1"
            },
            {
                bits: "5"
                name: slw
                desc: '''
                     
                '''
                swaccess: "rw"
                hwaccess: "hro"
                resval: "0"
            },
            {
                bits: "6"
                name: smt
                desc: '''
                     Schmit trigger enable
                '''
                swaccess: "rw"
                hwaccess: "hro"
                resval: "0"
            },
          ]
      }

       {
          name: A_56_MUX_SEL
          desc: '''
              Pad signal port multiplex selection for pad a_56. The programmed value defines which port
              is connected to the pad.
          '''
          swaccess: "rw"
          hwaccess: "hro"
          resval: 0
          fields: [
              {
                  bits: "1:0"
                  enum: [
                      { value: "0", name: "register", desc: "Connects the Pad to the internal configuration register."}
                      { value: "1", name: "port_cam1_cam_data6_i", desc: "Connect port cam_data6_i from port group cam1 to this pad." }
                      { value: "2", name: "port_spi7_spi_cs1", desc: "Connect port spi_cs1 from port group spi7 to this pad." }
                  ]
              }
          ]
      }

      {
          name: A_57_CFG
          desc: '''
            Pad signal configuration.
          '''
          swaccess: "rw"
          fields: [
            {
                bits: "0"
                name: chip2pad
                desc: '''
                     The signal that connects to the pads TX driver
                '''
                swaccess: "rw"
                hwaccess: "hro"
                resval: "0"
            },
            {
                bits: "2:1"
                name: drv
                desc: '''
                     Driving strength
                '''
                swaccess: "rw"
                hwaccess: "hro"
                resval: "0"
            },
            {
                bits: "3"
                name: oen
                desc: '''
                     Output enable signal, active low
                '''
                swaccess: "rw"
                hwaccess: "hro"
                resval: "1"
            },
            {
                bits: "4"
                name: puen
                desc: '''
                     Pull-Up enable signal, active low
                '''
                swaccess: "rw"
                hwaccess: "hro"
                resval: "1"
            },
            {
                bits: "5"
                name: slw
                desc: '''
                     
                '''
                swaccess: "rw"
                hwaccess: "hro"
                resval: "0"
            },
            {
                bits: "6"
                name: smt
                desc: '''
                     Schmit trigger enable
                '''
                swaccess: "rw"
                hwaccess: "hro"
                resval: "0"
            },
          ]
      }

       {
          name: A_57_MUX_SEL
          desc: '''
              Pad signal port multiplex selection for pad a_57. The programmed value defines which port
              is connected to the pad.
          '''
          swaccess: "rw"
          hwaccess: "hro"
          resval: 0
          fields: [
              {
                  bits: "1:0"
                  enum: [
                      { value: "0", name: "register", desc: "Connects the Pad to the internal configuration register."}
                      { value: "1", name: "port_cam1_cam_data7_i", desc: "Connect port cam_data7_i from port group cam1 to this pad." }
                      { value: "2", name: "port_i2c4_i2c_scl", desc: "Connect port i2c_scl from port group i2c4 to this pad." }
                  ]
              }
          ]
      }

      {
          name: A_58_CFG
          desc: '''
            Pad signal configuration.
          '''
          swaccess: "rw"
          fields: [
            {
                bits: "0"
                name: chip2pad
                desc: '''
                     The signal that connects to the pads TX driver
                '''
                swaccess: "rw"
                hwaccess: "hro"
                resval: "0"
            },
            {
                bits: "2:1"
                name: drv
                desc: '''
                     Driving strength
                '''
                swaccess: "rw"
                hwaccess: "hro"
                resval: "0"
            },
            {
                bits: "3"
                name: oen
                desc: '''
                     Output enable signal, active low
                '''
                swaccess: "rw"
                hwaccess: "hro"
                resval: "1"
            },
            {
                bits: "4"
                name: puen
                desc: '''
                     Pull-Up enable signal, active low
                '''
                swaccess: "rw"
                hwaccess: "hro"
                resval: "1"
            },
            {
                bits: "5"
                name: slw
                desc: '''
                     
                '''
                swaccess: "rw"
                hwaccess: "hro"
                resval: "0"
            },
            {
                bits: "6"
                name: smt
                desc: '''
                     Schmit trigger enable
                '''
                swaccess: "rw"
                hwaccess: "hro"
                resval: "0"
            },
          ]
      }

       {
          name: A_58_MUX_SEL
          desc: '''
              Pad signal port multiplex selection for pad a_58. The programmed value defines which port
              is connected to the pad.
          '''
          swaccess: "rw"
          hwaccess: "hro"
          resval: 0
          fields: [
              {
                  bits: "1:0"
                  enum: [
                      { value: "0", name: "register", desc: "Connects the Pad to the internal configuration register."}
                      { value: "1", name: "port_i2c4_i2c_sda", desc: "Connect port i2c_sda from port group i2c4 to this pad." }
                      { value: "2", name: "port_sdio1_sdio_data0", desc: "Connect port sdio_data0 from port group sdio1 to this pad." }
                  ]
              }
          ]
      }

      {
          name: A_59_CFG
          desc: '''
            Pad signal configuration.
          '''
          swaccess: "rw"
          fields: [
            {
                bits: "0"
                name: chip2pad
                desc: '''
                     The signal that connects to the pads TX driver
                '''
                swaccess: "rw"
                hwaccess: "hro"
                resval: "0"
            },
            {
                bits: "2:1"
                name: drv
                desc: '''
                     Driving strength
                '''
                swaccess: "rw"
                hwaccess: "hro"
                resval: "0"
            },
            {
                bits: "3"
                name: oen
                desc: '''
                     Output enable signal, active low
                '''
                swaccess: "rw"
                hwaccess: "hro"
                resval: "1"
            },
            {
                bits: "4"
                name: puen
                desc: '''
                     Pull-Up enable signal, active low
                '''
                swaccess: "rw"
                hwaccess: "hro"
                resval: "1"
            },
            {
                bits: "5"
                name: slw
                desc: '''
                     
                '''
                swaccess: "rw"
                hwaccess: "hro"
                resval: "0"
            },
            {
                bits: "6"
                name: smt
                desc: '''
                     Schmit trigger enable
                '''
                swaccess: "rw"
                hwaccess: "hro"
                resval: "0"
            },
          ]
      }

       {
          name: A_59_MUX_SEL
          desc: '''
              Pad signal port multiplex selection for pad a_59. The programmed value defines which port
              is connected to the pad.
          '''
          swaccess: "rw"
          hwaccess: "hro"
          resval: 0
          fields: [
              {
                  bits: "1:0"
                  enum: [
                      { value: "0", name: "register", desc: "Connects the Pad to the internal configuration register."}
                      { value: "1", name: "port_sdio1_sdio_data2", desc: "Connect port sdio_data2 from port group sdio1 to this pad." }
                      { value: "2", name: "port_uart1_uart_tx", desc: "Connect port uart_tx from port group uart1 to this pad." }
                  ]
              }
          ]
      }

      {
          name: A_60_CFG
          desc: '''
            Pad signal configuration.
          '''
          swaccess: "rw"
          fields: [
            {
                bits: "0"
                name: chip2pad
                desc: '''
                     The signal that connects to the pads TX driver
                '''
                swaccess: "rw"
                hwaccess: "hro"
                resval: "0"
            },
            {
                bits: "2:1"
                name: drv
                desc: '''
                     Driving strength
                '''
                swaccess: "rw"
                hwaccess: "hro"
                resval: "0"
            },
            {
                bits: "3"
                name: oen
                desc: '''
                     Output enable signal, active low
                '''
                swaccess: "rw"
                hwaccess: "hro"
                resval: "1"
            },
            {
                bits: "4"
                name: puen
                desc: '''
                     Pull-Up enable signal, active low
                '''
                swaccess: "rw"
                hwaccess: "hro"
                resval: "1"
            },
            {
                bits: "5"
                name: slw
                desc: '''
                     
                '''
                swaccess: "rw"
                hwaccess: "hro"
                resval: "0"
            },
            {
                bits: "6"
                name: smt
                desc: '''
                     Schmit trigger enable
                '''
                swaccess: "rw"
                hwaccess: "hro"
                resval: "0"
            },
          ]
      }

       {
          name: A_60_MUX_SEL
          desc: '''
              Pad signal port multiplex selection for pad a_60. The programmed value defines which port
              is connected to the pad.
          '''
          swaccess: "rw"
          hwaccess: "hro"
          resval: 0
          fields: [
              {
                  bits: "1:0"
                  enum: [
                      { value: "0", name: "register", desc: "Connects the Pad to the internal configuration register."}
                      { value: "1", name: "port_sdio1_sdio_data3", desc: "Connect port sdio_data3 from port group sdio1 to this pad." }
                      { value: "2", name: "port_uart1_uart_rx", desc: "Connect port uart_rx from port group uart1 to this pad." }
                  ]
              }
          ]
      }

      {
          name: A_61_CFG
          desc: '''
            Pad signal configuration.
          '''
          swaccess: "rw"
          fields: [
            {
                bits: "0"
                name: chip2pad
                desc: '''
                     The signal that connects to the pads TX driver
                '''
                swaccess: "rw"
                hwaccess: "hro"
                resval: "0"
            },
            {
                bits: "2:1"
                name: drv
                desc: '''
                     Driving strength
                '''
                swaccess: "rw"
                hwaccess: "hro"
                resval: "0"
            },
            {
                bits: "3"
                name: oen
                desc: '''
                     Output enable signal, active low
                '''
                swaccess: "rw"
                hwaccess: "hro"
                resval: "1"
            },
            {
                bits: "4"
                name: puen
                desc: '''
                     Pull-Up enable signal, active low
                '''
                swaccess: "rw"
                hwaccess: "hro"
                resval: "1"
            },
            {
                bits: "5"
                name: slw
                desc: '''
                     
                '''
                swaccess: "rw"
                hwaccess: "hro"
                resval: "0"
            },
            {
                bits: "6"
                name: smt
                desc: '''
                     Schmit trigger enable
                '''
                swaccess: "rw"
                hwaccess: "hro"
                resval: "0"
            },
          ]
      }

       {
          name: A_61_MUX_SEL
          desc: '''
              Pad signal port multiplex selection for pad a_61. The programmed value defines which port
              is connected to the pad.
          '''
          swaccess: "rw"
          hwaccess: "hro"
          resval: 0
          fields: [
              {
                  bits: "1:0"
                  enum: [
                      { value: "0", name: "register", desc: "Connects the Pad to the internal configuration register."}
                      { value: "1", name: "port_sdio1_sdio_clk", desc: "Connect port sdio_clk from port group sdio1 to this pad." }
                      { value: "2", name: "port_usart1_uart_tx", desc: "Connect port uart_tx from port group usart1 to this pad." }
                  ]
              }
          ]
      }

      {
          name: A_62_CFG
          desc: '''
            Pad signal configuration.
          '''
          swaccess: "rw"
          fields: [
            {
                bits: "0"
                name: chip2pad
                desc: '''
                     The signal that connects to the pads TX driver
                '''
                swaccess: "rw"
                hwaccess: "hro"
                resval: "0"
            },
            {
                bits: "2:1"
                name: drv
                desc: '''
                     Driving strength
                '''
                swaccess: "rw"
                hwaccess: "hro"
                resval: "0"
            },
            {
                bits: "3"
                name: oen
                desc: '''
                     Output enable signal, active low
                '''
                swaccess: "rw"
                hwaccess: "hro"
                resval: "1"
            },
            {
                bits: "4"
                name: puen
                desc: '''
                     Pull-Up enable signal, active low
                '''
                swaccess: "rw"
                hwaccess: "hro"
                resval: "1"
            },
            {
                bits: "5"
                name: slw
                desc: '''
                     
                '''
                swaccess: "rw"
                hwaccess: "hro"
                resval: "0"
            },
            {
                bits: "6"
                name: smt
                desc: '''
                     Schmit trigger enable
                '''
                swaccess: "rw"
                hwaccess: "hro"
                resval: "0"
            },
          ]
      }

       {
          name: A_62_MUX_SEL
          desc: '''
              Pad signal port multiplex selection for pad a_62. The programmed value defines which port
              is connected to the pad.
          '''
          swaccess: "rw"
          hwaccess: "hro"
          resval: 0
          fields: [
              {
                  bits: "1:0"
                  enum: [
                      { value: "0", name: "register", desc: "Connects the Pad to the internal configuration register."}
                      { value: "1", name: "port_sdio1_sdio_cmd", desc: "Connect port sdio_cmd from port group sdio1 to this pad." }
                      { value: "2", name: "port_usart1_uart_rx", desc: "Connect port uart_rx from port group usart1 to this pad." }
                  ]
              }
          ]
      }

      {
          name: A_63_CFG
          desc: '''
            Pad signal configuration.
          '''
          swaccess: "rw"
          fields: [
            {
                bits: "0"
                name: chip2pad
                desc: '''
                     The signal that connects to the pads TX driver
                '''
                swaccess: "rw"
                hwaccess: "hro"
                resval: "0"
            },
            {
                bits: "2:1"
                name: drv
                desc: '''
                     Driving strength
                '''
                swaccess: "rw"
                hwaccess: "hro"
                resval: "0"
            },
            {
                bits: "3"
                name: oen
                desc: '''
                     Output enable signal, active low
                '''
                swaccess: "rw"
                hwaccess: "hro"
                resval: "1"
            },
            {
                bits: "4"
                name: puen
                desc: '''
                     Pull-Up enable signal, active low
                '''
                swaccess: "rw"
                hwaccess: "hro"
                resval: "1"
            },
            {
                bits: "5"
                name: slw
                desc: '''
                     
                '''
                swaccess: "rw"
                hwaccess: "hro"
                resval: "0"
            },
            {
                bits: "6"
                name: smt
                desc: '''
                     Schmit trigger enable
                '''
                swaccess: "rw"
                hwaccess: "hro"
                resval: "0"
            },
          ]
      }

       {
          name: A_63_MUX_SEL
          desc: '''
              Pad signal port multiplex selection for pad a_63. The programmed value defines which port
              is connected to the pad.
          '''
          swaccess: "rw"
          hwaccess: "hro"
          resval: 0
          fields: [
              {
                  bits: "0:0"
                  enum: [
                      { value: "0", name: "register", desc: "Connects the Pad to the internal configuration register."}
                      { value: "1", name: "port_usart1_uart_rts", desc: "Connect port uart_rts from port group usart1 to this pad." }
                  ]
              }
          ]
      }

      {
          name: A_64_CFG
          desc: '''
            Pad signal configuration.
          '''
          swaccess: "rw"
          fields: [
            {
                bits: "0"
                name: chip2pad
                desc: '''
                     The signal that connects to the pads TX driver
                '''
                swaccess: "rw"
                hwaccess: "hro"
                resval: "0"
            },
            {
                bits: "2:1"
                name: drv
                desc: '''
                     Driving strength
                '''
                swaccess: "rw"
                hwaccess: "hro"
                resval: "0"
            },
            {
                bits: "3"
                name: oen
                desc: '''
                     Output enable signal, active low
                '''
                swaccess: "rw"
                hwaccess: "hro"
                resval: "1"
            },
            {
                bits: "4"
                name: puen
                desc: '''
                     Pull-Up enable signal, active low
                '''
                swaccess: "rw"
                hwaccess: "hro"
                resval: "1"
            },
            {
                bits: "5"
                name: slw
                desc: '''
                     
                '''
                swaccess: "rw"
                hwaccess: "hro"
                resval: "0"
            },
            {
                bits: "6"
                name: smt
                desc: '''
                     Schmit trigger enable
                '''
                swaccess: "rw"
                hwaccess: "hro"
                resval: "0"
            },
          ]
      }

       {
          name: A_64_MUX_SEL
          desc: '''
              Pad signal port multiplex selection for pad a_64. The programmed value defines which port
              is connected to the pad.
          '''
          swaccess: "rw"
          hwaccess: "hro"
          resval: 0
          fields: [
              {
                  bits: "0:0"
                  enum: [
                      { value: "0", name: "register", desc: "Connects the Pad to the internal configuration register."}
                      { value: "1", name: "port_usart1_uart_cts", desc: "Connect port uart_cts from port group usart1 to this pad." }
                  ]
              }
          ]
      }

      {
          name: A_65_CFG
          desc: '''
            Pad signal configuration.
          '''
          swaccess: "rw"
          fields: [
            {
                bits: "0"
                name: chip2pad
                desc: '''
                     The signal that connects to the pads TX driver
                '''
                swaccess: "rw"
                hwaccess: "hro"
                resval: "0"
            },
            {
                bits: "2:1"
                name: drv
                desc: '''
                     Driving strength
                '''
                swaccess: "rw"
                hwaccess: "hro"
                resval: "0"
            },
            {
                bits: "3"
                name: oen
                desc: '''
                     Output enable signal, active low
                '''
                swaccess: "rw"
                hwaccess: "hro"
                resval: "1"
            },
            {
                bits: "4"
                name: puen
                desc: '''
                     Pull-Up enable signal, active low
                '''
                swaccess: "rw"
                hwaccess: "hro"
                resval: "1"
            },
            {
                bits: "5"
                name: slw
                desc: '''
                     
                '''
                swaccess: "rw"
                hwaccess: "hro"
                resval: "0"
            },
            {
                bits: "6"
                name: smt
                desc: '''
                     Schmit trigger enable
                '''
                swaccess: "rw"
                hwaccess: "hro"
                resval: "0"
            },
          ]
      }

       {
          name: A_65_MUX_SEL
          desc: '''
              Pad signal port multiplex selection for pad a_65. The programmed value defines which port
              is connected to the pad.
          '''
          swaccess: "rw"
          hwaccess: "hro"
          resval: 0
          fields: [
              {
                  bits: "0:0"
                  enum: [
                      { value: "0", name: "register", desc: "Connects the Pad to the internal configuration register."}
                      { value: "1", name: "port_uart2_uart_tx", desc: "Connect port uart_tx from port group uart2 to this pad." }
                  ]
              }
          ]
      }

      {
          name: A_66_CFG
          desc: '''
            Pad signal configuration.
          '''
          swaccess: "rw"
          fields: [
            {
                bits: "0"
                name: chip2pad
                desc: '''
                     The signal that connects to the pads TX driver
                '''
                swaccess: "rw"
                hwaccess: "hro"
                resval: "0"
            },
            {
                bits: "2:1"
                name: drv
                desc: '''
                     Driving strength
                '''
                swaccess: "rw"
                hwaccess: "hro"
                resval: "0"
            },
            {
                bits: "3"
                name: oen
                desc: '''
                     Output enable signal, active low
                '''
                swaccess: "rw"
                hwaccess: "hro"
                resval: "1"
            },
            {
                bits: "4"
                name: puen
                desc: '''
                     Pull-Up enable signal, active low
                '''
                swaccess: "rw"
                hwaccess: "hro"
                resval: "1"
            },
            {
                bits: "5"
                name: slw
                desc: '''
                     
                '''
                swaccess: "rw"
                hwaccess: "hro"
                resval: "0"
            },
            {
                bits: "6"
                name: smt
                desc: '''
                     Schmit trigger enable
                '''
                swaccess: "rw"
                hwaccess: "hro"
                resval: "0"
            },
          ]
      }

       {
          name: A_66_MUX_SEL
          desc: '''
              Pad signal port multiplex selection for pad a_66. The programmed value defines which port
              is connected to the pad.
          '''
          swaccess: "rw"
          hwaccess: "hro"
          resval: 0
          fields: [
              {
                  bits: "0:0"
                  enum: [
                      { value: "0", name: "register", desc: "Connects the Pad to the internal configuration register."}
                      { value: "1", name: "port_uart2_uart_rx", desc: "Connect port uart_rx from port group uart2 to this pad." }
                  ]
              }
          ]
      }

      {
          name: A_67_CFG
          desc: '''
            Pad signal configuration.
          '''
          swaccess: "rw"
          fields: [
            {
                bits: "0"
                name: chip2pad
                desc: '''
                     The signal that connects to the pads TX driver
                '''
                swaccess: "rw"
                hwaccess: "hro"
                resval: "0"
            },
            {
                bits: "2:1"
                name: drv
                desc: '''
                     Driving strength
                '''
                swaccess: "rw"
                hwaccess: "hro"
                resval: "0"
            },
            {
                bits: "3"
                name: oen
                desc: '''
                     Output enable signal, active low
                '''
                swaccess: "rw"
                hwaccess: "hro"
                resval: "1"
            },
            {
                bits: "4"
                name: puen
                desc: '''
                     Pull-Up enable signal, active low
                '''
                swaccess: "rw"
                hwaccess: "hro"
                resval: "1"
            },
            {
                bits: "5"
                name: slw
                desc: '''
                     
                '''
                swaccess: "rw"
                hwaccess: "hro"
                resval: "0"
            },
            {
                bits: "6"
                name: smt
                desc: '''
                     Schmit trigger enable
                '''
                swaccess: "rw"
                hwaccess: "hro"
                resval: "0"
            },
          ]
      }

       {
          name: A_67_MUX_SEL
          desc: '''
              Pad signal port multiplex selection for pad a_67. The programmed value defines which port
              is connected to the pad.
          '''
          swaccess: "rw"
          hwaccess: "hro"
          resval: 0
          fields: [
              {
                  bits: "0:0"
                  enum: [
                      { value: "0", name: "register", desc: "Connects the Pad to the internal configuration register."}
                      { value: "1", name: "port_i2c5_i2c_scl", desc: "Connect port i2c_scl from port group i2c5 to this pad." }
                  ]
              }
          ]
      }

      {
          name: A_68_CFG
          desc: '''
            Pad signal configuration.
          '''
          swaccess: "rw"
          fields: [
            {
                bits: "0"
                name: chip2pad
                desc: '''
                     The signal that connects to the pads TX driver
                '''
                swaccess: "rw"
                hwaccess: "hro"
                resval: "0"
            },
            {
                bits: "2:1"
                name: drv
                desc: '''
                     Driving strength
                '''
                swaccess: "rw"
                hwaccess: "hro"
                resval: "0"
            },
            {
                bits: "3"
                name: oen
                desc: '''
                     Output enable signal, active low
                '''
                swaccess: "rw"
                hwaccess: "hro"
                resval: "1"
            },
            {
                bits: "4"
                name: puen
                desc: '''
                     Pull-Up enable signal, active low
                '''
                swaccess: "rw"
                hwaccess: "hro"
                resval: "1"
            },
            {
                bits: "5"
                name: slw
                desc: '''
                     
                '''
                swaccess: "rw"
                hwaccess: "hro"
                resval: "0"
            },
            {
                bits: "6"
                name: smt
                desc: '''
                     Schmit trigger enable
                '''
                swaccess: "rw"
                hwaccess: "hro"
                resval: "0"
            },
          ]
      }

       {
          name: A_68_MUX_SEL
          desc: '''
              Pad signal port multiplex selection for pad a_68. The programmed value defines which port
              is connected to the pad.
          '''
          swaccess: "rw"
          hwaccess: "hro"
          resval: 0
          fields: [
              {
                  bits: "0:0"
                  enum: [
                      { value: "0", name: "register", desc: "Connects the Pad to the internal configuration register."}
                      { value: "1", name: "port_i2c5_i2c_sda", desc: "Connect port i2c_sda from port group i2c5 to this pad." }
                  ]
              }
          ]
      }

      {
          name: A_69_CFG
          desc: '''
            Pad signal configuration.
          '''
          swaccess: "rw"
          fields: [
            {
                bits: "0"
                name: chip2pad
                desc: '''
                     The signal that connects to the pads TX driver
                '''
                swaccess: "rw"
                hwaccess: "hro"
                resval: "0"
            },
            {
                bits: "2:1"
                name: drv
                desc: '''
                     Driving strength
                '''
                swaccess: "rw"
                hwaccess: "hro"
                resval: "0"
            },
            {
                bits: "3"
                name: oen
                desc: '''
                     Output enable signal, active low
                '''
                swaccess: "rw"
                hwaccess: "hro"
                resval: "1"
            },
            {
                bits: "4"
                name: puen
                desc: '''
                     Pull-Up enable signal, active low
                '''
                swaccess: "rw"
                hwaccess: "hro"
                resval: "1"
            },
            {
                bits: "5"
                name: slw
                desc: '''
                     
                '''
                swaccess: "rw"
                hwaccess: "hro"
                resval: "0"
            },
            {
                bits: "6"
                name: smt
                desc: '''
                     Schmit trigger enable
                '''
                swaccess: "rw"
                hwaccess: "hro"
                resval: "0"
            },
          ]
      }

       {
          name: A_69_MUX_SEL
          desc: '''
              Pad signal port multiplex selection for pad a_69. The programmed value defines which port
              is connected to the pad.
          '''
          swaccess: "rw"
          hwaccess: "hro"
          resval: 0
          fields: [
              {
                  bits: "0:0"
                  enum: [
                      { value: "0", name: "register", desc: "Connects the Pad to the internal configuration register."}
                      { value: "1", name: "port_usart2_uart_tx", desc: "Connect port uart_tx from port group usart2 to this pad." }
                  ]
              }
          ]
      }

      {
          name: A_70_CFG
          desc: '''
            Pad signal configuration.
          '''
          swaccess: "rw"
          fields: [
            {
                bits: "0"
                name: chip2pad
                desc: '''
                     The signal that connects to the pads TX driver
                '''
                swaccess: "rw"
                hwaccess: "hro"
                resval: "0"
            },
            {
                bits: "2:1"
                name: drv
                desc: '''
                     Driving strength
                '''
                swaccess: "rw"
                hwaccess: "hro"
                resval: "0"
            },
            {
                bits: "3"
                name: oen
                desc: '''
                     Output enable signal, active low
                '''
                swaccess: "rw"
                hwaccess: "hro"
                resval: "1"
            },
            {
                bits: "4"
                name: puen
                desc: '''
                     Pull-Up enable signal, active low
                '''
                swaccess: "rw"
                hwaccess: "hro"
                resval: "1"
            },
            {
                bits: "5"
                name: slw
                desc: '''
                     
                '''
                swaccess: "rw"
                hwaccess: "hro"
                resval: "0"
            },
            {
                bits: "6"
                name: smt
                desc: '''
                     Schmit trigger enable
                '''
                swaccess: "rw"
                hwaccess: "hro"
                resval: "0"
            },
          ]
      }

       {
          name: A_70_MUX_SEL
          desc: '''
              Pad signal port multiplex selection for pad a_70. The programmed value defines which port
              is connected to the pad.
          '''
          swaccess: "rw"
          hwaccess: "hro"
          resval: 0
          fields: [
              {
                  bits: "0:0"
                  enum: [
                      { value: "0", name: "register", desc: "Connects the Pad to the internal configuration register."}
                      { value: "1", name: "port_usart2_uart_rx", desc: "Connect port uart_rx from port group usart2 to this pad." }
                  ]
              }
          ]
      }

      {
          name: A_71_CFG
          desc: '''
            Pad signal configuration.
          '''
          swaccess: "rw"
          fields: [
            {
                bits: "0"
                name: chip2pad
                desc: '''
                     The signal that connects to the pads TX driver
                '''
                swaccess: "rw"
                hwaccess: "hro"
                resval: "0"
            },
            {
                bits: "2:1"
                name: drv
                desc: '''
                     Driving strength
                '''
                swaccess: "rw"
                hwaccess: "hro"
                resval: "0"
            },
            {
                bits: "3"
                name: oen
                desc: '''
                     Output enable signal, active low
                '''
                swaccess: "rw"
                hwaccess: "hro"
                resval: "1"
            },
            {
                bits: "4"
                name: puen
                desc: '''
                     Pull-Up enable signal, active low
                '''
                swaccess: "rw"
                hwaccess: "hro"
                resval: "1"
            },
            {
                bits: "5"
                name: slw
                desc: '''
                     
                '''
                swaccess: "rw"
                hwaccess: "hro"
                resval: "0"
            },
            {
                bits: "6"
                name: smt
                desc: '''
                     Schmit trigger enable
                '''
                swaccess: "rw"
                hwaccess: "hro"
                resval: "0"
            },
          ]
      }

       {
          name: A_71_MUX_SEL
          desc: '''
              Pad signal port multiplex selection for pad a_71. The programmed value defines which port
              is connected to the pad.
          '''
          swaccess: "rw"
          hwaccess: "hro"
          resval: 0
          fields: [
              {
                  bits: "0:0"
                  enum: [
                      { value: "0", name: "register", desc: "Connects the Pad to the internal configuration register."}
                      { value: "1", name: "port_usart2_uart_rts", desc: "Connect port uart_rts from port group usart2 to this pad." }
                  ]
              }
          ]
      }

      {
          name: A_72_CFG
          desc: '''
            Pad signal configuration.
          '''
          swaccess: "rw"
          fields: [
            {
                bits: "0"
                name: chip2pad
                desc: '''
                     The signal that connects to the pads TX driver
                '''
                swaccess: "rw"
                hwaccess: "hro"
                resval: "0"
            },
            {
                bits: "2:1"
                name: drv
                desc: '''
                     Driving strength
                '''
                swaccess: "rw"
                hwaccess: "hro"
                resval: "0"
            },
            {
                bits: "3"
                name: oen
                desc: '''
                     Output enable signal, active low
                '''
                swaccess: "rw"
                hwaccess: "hro"
                resval: "1"
            },
            {
                bits: "4"
                name: puen
                desc: '''
                     Pull-Up enable signal, active low
                '''
                swaccess: "rw"
                hwaccess: "hro"
                resval: "1"
            },
            {
                bits: "5"
                name: slw
                desc: '''
                     
                '''
                swaccess: "rw"
                hwaccess: "hro"
                resval: "0"
            },
            {
                bits: "6"
                name: smt
                desc: '''
                     Schmit trigger enable
                '''
                swaccess: "rw"
                hwaccess: "hro"
                resval: "0"
            },
          ]
      }

       {
          name: A_72_MUX_SEL
          desc: '''
              Pad signal port multiplex selection for pad a_72. The programmed value defines which port
              is connected to the pad.
          '''
          swaccess: "rw"
          hwaccess: "hro"
          resval: 0
          fields: [
              {
                  bits: "0:0"
                  enum: [
                      { value: "0", name: "register", desc: "Connects the Pad to the internal configuration register."}
                      { value: "1", name: "port_usart2_uart_cts", desc: "Connect port uart_cts from port group usart2 to this pad." }
                  ]
              }
          ]
      }

      {
          name: A_73_CFG
          desc: '''
            Pad signal configuration.
          '''
          swaccess: "rw"
          fields: [
            {
                bits: "0"
                name: chip2pad
                desc: '''
                     The signal that connects to the pads TX driver
                '''
                swaccess: "rw"
                hwaccess: "hro"
                resval: "0"
            },
            {
                bits: "2:1"
                name: drv
                desc: '''
                     Driving strength
                '''
                swaccess: "rw"
                hwaccess: "hro"
                resval: "0"
            },
            {
                bits: "3"
                name: oen
                desc: '''
                     Output enable signal, active low
                '''
                swaccess: "rw"
                hwaccess: "hro"
                resval: "1"
            },
            {
                bits: "4"
                name: puen
                desc: '''
                     Pull-Up enable signal, active low
                '''
                swaccess: "rw"
                hwaccess: "hro"
                resval: "1"
            },
            {
                bits: "5"
                name: slw
                desc: '''
                     
                '''
                swaccess: "rw"
                hwaccess: "hro"
                resval: "0"
            },
            {
                bits: "6"
                name: smt
                desc: '''
                     Schmit trigger enable
                '''
                swaccess: "rw"
                hwaccess: "hro"
                resval: "0"
            },
          ]
      }

       {
          name: A_73_MUX_SEL
          desc: '''
              Pad signal port multiplex selection for pad a_73. The programmed value defines which port
              is connected to the pad.
          '''
          swaccess: "rw"
          hwaccess: "hro"
          resval: 0
          fields: [
              {
                  bits: "0:0"
                  enum: [
                      { value: "0", name: "register", desc: "Connects the Pad to the internal configuration register."}
                      { value: "1", name: "port_usart3_uart_tx", desc: "Connect port uart_tx from port group usart3 to this pad." }
                  ]
              }
          ]
      }

      {
          name: A_74_CFG
          desc: '''
            Pad signal configuration.
          '''
          swaccess: "rw"
          fields: [
            {
                bits: "0"
                name: chip2pad
                desc: '''
                     The signal that connects to the pads TX driver
                '''
                swaccess: "rw"
                hwaccess: "hro"
                resval: "0"
            },
            {
                bits: "2:1"
                name: drv
                desc: '''
                     Driving strength
                '''
                swaccess: "rw"
                hwaccess: "hro"
                resval: "0"
            },
            {
                bits: "3"
                name: oen
                desc: '''
                     Output enable signal, active low
                '''
                swaccess: "rw"
                hwaccess: "hro"
                resval: "1"
            },
            {
                bits: "4"
                name: puen
                desc: '''
                     Pull-Up enable signal, active low
                '''
                swaccess: "rw"
                hwaccess: "hro"
                resval: "1"
            },
            {
                bits: "5"
                name: slw
                desc: '''
                     
                '''
                swaccess: "rw"
                hwaccess: "hro"
                resval: "0"
            },
            {
                bits: "6"
                name: smt
                desc: '''
                     Schmit trigger enable
                '''
                swaccess: "rw"
                hwaccess: "hro"
                resval: "0"
            },
          ]
      }

       {
          name: A_74_MUX_SEL
          desc: '''
              Pad signal port multiplex selection for pad a_74. The programmed value defines which port
              is connected to the pad.
          '''
          swaccess: "rw"
          hwaccess: "hro"
          resval: 0
          fields: [
              {
                  bits: "0:0"
                  enum: [
                      { value: "0", name: "register", desc: "Connects the Pad to the internal configuration register."}
                      { value: "1", name: "port_usart3_uart_rx", desc: "Connect port uart_rx from port group usart3 to this pad." }
                  ]
              }
          ]
      }

      {
          name: A_75_CFG
          desc: '''
            Pad signal configuration.
          '''
          swaccess: "rw"
          fields: [
            {
                bits: "0"
                name: chip2pad
                desc: '''
                     The signal that connects to the pads TX driver
                '''
                swaccess: "rw"
                hwaccess: "hro"
                resval: "0"
            },
            {
                bits: "2:1"
                name: drv
                desc: '''
                     Driving strength
                '''
                swaccess: "rw"
                hwaccess: "hro"
                resval: "0"
            },
            {
                bits: "3"
                name: oen
                desc: '''
                     Output enable signal, active low
                '''
                swaccess: "rw"
                hwaccess: "hro"
                resval: "1"
            },
            {
                bits: "4"
                name: puen
                desc: '''
                     Pull-Up enable signal, active low
                '''
                swaccess: "rw"
                hwaccess: "hro"
                resval: "1"
            },
            {
                bits: "5"
                name: slw
                desc: '''
                     
                '''
                swaccess: "rw"
                hwaccess: "hro"
                resval: "0"
            },
            {
                bits: "6"
                name: smt
                desc: '''
                     Schmit trigger enable
                '''
                swaccess: "rw"
                hwaccess: "hro"
                resval: "0"
            },
          ]
      }

       {
          name: A_75_MUX_SEL
          desc: '''
              Pad signal port multiplex selection for pad a_75. The programmed value defines which port
              is connected to the pad.
          '''
          swaccess: "rw"
          hwaccess: "hro"
          resval: 0
          fields: [
              {
                  bits: "0:0"
                  enum: [
                      { value: "0", name: "register", desc: "Connects the Pad to the internal configuration register."}
                      { value: "1", name: "port_usart3_uart_rts", desc: "Connect port uart_rts from port group usart3 to this pad." }
                  ]
              }
          ]
      }

      {
          name: A_76_CFG
          desc: '''
            Pad signal configuration.
          '''
          swaccess: "rw"
          fields: [
            {
                bits: "0"
                name: chip2pad
                desc: '''
                     The signal that connects to the pads TX driver
                '''
                swaccess: "rw"
                hwaccess: "hro"
                resval: "0"
            },
            {
                bits: "2:1"
                name: drv
                desc: '''
                     Driving strength
                '''
                swaccess: "rw"
                hwaccess: "hro"
                resval: "0"
            },
            {
                bits: "3"
                name: oen
                desc: '''
                     Output enable signal, active low
                '''
                swaccess: "rw"
                hwaccess: "hro"
                resval: "1"
            },
            {
                bits: "4"
                name: puen
                desc: '''
                     Pull-Up enable signal, active low
                '''
                swaccess: "rw"
                hwaccess: "hro"
                resval: "1"
            },
            {
                bits: "5"
                name: slw
                desc: '''
                     
                '''
                swaccess: "rw"
                hwaccess: "hro"
                resval: "0"
            },
            {
                bits: "6"
                name: smt
                desc: '''
                     Schmit trigger enable
                '''
                swaccess: "rw"
                hwaccess: "hro"
                resval: "0"
            },
          ]
      }

       {
          name: A_76_MUX_SEL
          desc: '''
              Pad signal port multiplex selection for pad a_76. The programmed value defines which port
              is connected to the pad.
          '''
          swaccess: "rw"
          hwaccess: "hro"
          resval: 0
          fields: [
              {
                  bits: "0:0"
                  enum: [
                      { value: "0", name: "register", desc: "Connects the Pad to the internal configuration register."}
                      { value: "1", name: "port_usart3_uart_cts", desc: "Connect port uart_cts from port group usart3 to this pad." }
                  ]
              }
          ]
      }

      {
          name: A_77_CFG
          desc: '''
            Pad signal configuration.
          '''
          swaccess: "rw"
          fields: [
            {
                bits: "0"
                name: chip2pad
                desc: '''
                     The signal that connects to the pads TX driver
                '''
                swaccess: "rw"
                hwaccess: "hro"
                resval: "0"
            },
            {
                bits: "2:1"
                name: drv
                desc: '''
                     Driving strength
                '''
                swaccess: "rw"
                hwaccess: "hro"
                resval: "0"
            },
            {
                bits: "3"
                name: oen
                desc: '''
                     Output enable signal, active low
                '''
                swaccess: "rw"
                hwaccess: "hro"
                resval: "1"
            },
            {
                bits: "4"
                name: puen
                desc: '''
                     Pull-Up enable signal, active low
                '''
                swaccess: "rw"
                hwaccess: "hro"
                resval: "1"
            },
            {
                bits: "5"
                name: slw
                desc: '''
                     
                '''
                swaccess: "rw"
                hwaccess: "hro"
                resval: "0"
            },
            {
                bits: "6"
                name: smt
                desc: '''
                     Schmit trigger enable
                '''
                swaccess: "rw"
                hwaccess: "hro"
                resval: "0"
            },
          ]
      }

       {
          name: A_77_MUX_SEL
          desc: '''
              Pad signal port multiplex selection for pad a_77. The programmed value defines which port
              is connected to the pad.
          '''
          swaccess: "rw"
          hwaccess: "hro"
          resval: 0
          fields: [
              {
                  bits: "0:0"
                  enum: [
                      { value: "0", name: "register", desc: "Connects the Pad to the internal configuration register."}
                      { value: "1", name: "port_pwm1_pwm0", desc: "Connect port pwm0 from port group pwm1 to this pad." }
                  ]
              }
          ]
      }

      {
          name: A_78_CFG
          desc: '''
            Pad signal configuration.
          '''
          swaccess: "rw"
          fields: [
            {
                bits: "0"
                name: chip2pad
                desc: '''
                     The signal that connects to the pads TX driver
                '''
                swaccess: "rw"
                hwaccess: "hro"
                resval: "0"
            },
            {
                bits: "2:1"
                name: drv
                desc: '''
                     Driving strength
                '''
                swaccess: "rw"
                hwaccess: "hro"
                resval: "0"
            },
            {
                bits: "3"
                name: oen
                desc: '''
                     Output enable signal, active low
                '''
                swaccess: "rw"
                hwaccess: "hro"
                resval: "1"
            },
            {
                bits: "4"
                name: puen
                desc: '''
                     Pull-Up enable signal, active low
                '''
                swaccess: "rw"
                hwaccess: "hro"
                resval: "1"
            },
            {
                bits: "5"
                name: slw
                desc: '''
                     
                '''
                swaccess: "rw"
                hwaccess: "hro"
                resval: "0"
            },
            {
                bits: "6"
                name: smt
                desc: '''
                     Schmit trigger enable
                '''
                swaccess: "rw"
                hwaccess: "hro"
                resval: "0"
            },
          ]
      }

       {
          name: A_78_MUX_SEL
          desc: '''
              Pad signal port multiplex selection for pad a_78. The programmed value defines which port
              is connected to the pad.
          '''
          swaccess: "rw"
          hwaccess: "hro"
          resval: 0
          fields: [
              {
                  bits: "0:0"
                  enum: [
                      { value: "0", name: "register", desc: "Connects the Pad to the internal configuration register."}
                      { value: "1", name: "port_pwm1_pwm1", desc: "Connect port pwm1 from port group pwm1 to this pad." }
                  ]
              }
          ]
      }

      {
          name: A_79_CFG
          desc: '''
            Pad signal configuration.
          '''
          swaccess: "rw"
          fields: [
            {
                bits: "0"
                name: chip2pad
                desc: '''
                     The signal that connects to the pads TX driver
                '''
                swaccess: "rw"
                hwaccess: "hro"
                resval: "0"
            },
            {
                bits: "2:1"
                name: drv
                desc: '''
                     Driving strength
                '''
                swaccess: "rw"
                hwaccess: "hro"
                resval: "0"
            },
            {
                bits: "3"
                name: oen
                desc: '''
                     Output enable signal, active low
                '''
                swaccess: "rw"
                hwaccess: "hro"
                resval: "1"
            },
            {
                bits: "4"
                name: puen
                desc: '''
                     Pull-Up enable signal, active low
                '''
                swaccess: "rw"
                hwaccess: "hro"
                resval: "1"
            },
            {
                bits: "5"
                name: slw
                desc: '''
                     
                '''
                swaccess: "rw"
                hwaccess: "hro"
                resval: "0"
            },
            {
                bits: "6"
                name: smt
                desc: '''
                     Schmit trigger enable
                '''
                swaccess: "rw"
                hwaccess: "hro"
                resval: "0"
            },
          ]
      }

       {
          name: A_79_MUX_SEL
          desc: '''
              Pad signal port multiplex selection for pad a_79. The programmed value defines which port
              is connected to the pad.
          '''
          swaccess: "rw"
          hwaccess: "hro"
          resval: 0
          fields: [
              {
                  bits: "0:0"
                  enum: [
                      { value: "0", name: "register", desc: "Connects the Pad to the internal configuration register."}
                      { value: "1", name: "port_pwm1_pwm2", desc: "Connect port pwm2 from port group pwm1 to this pad." }
                  ]
              }
          ]
      }

      {
          name: A_80_CFG
          desc: '''
            Pad signal configuration.
          '''
          swaccess: "rw"
          fields: [
            {
                bits: "0"
                name: chip2pad
                desc: '''
                     The signal that connects to the pads TX driver
                '''
                swaccess: "rw"
                hwaccess: "hro"
                resval: "0"
            },
            {
                bits: "2:1"
                name: drv
                desc: '''
                     Driving strength
                '''
                swaccess: "rw"
                hwaccess: "hro"
                resval: "0"
            },
            {
                bits: "3"
                name: oen
                desc: '''
                     Output enable signal, active low
                '''
                swaccess: "rw"
                hwaccess: "hro"
                resval: "1"
            },
            {
                bits: "4"
                name: puen
                desc: '''
                     Pull-Up enable signal, active low
                '''
                swaccess: "rw"
                hwaccess: "hro"
                resval: "1"
            },
            {
                bits: "5"
                name: slw
                desc: '''
                     
                '''
                swaccess: "rw"
                hwaccess: "hro"
                resval: "0"
            },
            {
                bits: "6"
                name: smt
                desc: '''
                     Schmit trigger enable
                '''
                swaccess: "rw"
                hwaccess: "hro"
                resval: "0"
            },
          ]
      }

       {
          name: A_80_MUX_SEL
          desc: '''
              Pad signal port multiplex selection for pad a_80. The programmed value defines which port
              is connected to the pad.
          '''
          swaccess: "rw"
          hwaccess: "hro"
          resval: 0
          fields: [
              {
                  bits: "0:0"
                  enum: [
                      { value: "0", name: "register", desc: "Connects the Pad to the internal configuration register."}
                      { value: "1", name: "port_pwm1_pwm3", desc: "Connect port pwm3 from port group pwm1 to this pad." }
                  ]
              }
          ]
      }

      {
          name: A_81_CFG
          desc: '''
            Pad signal configuration.
          '''
          swaccess: "rw"
          fields: [
            {
                bits: "0"
                name: chip2pad
                desc: '''
                     The signal that connects to the pads TX driver
                '''
                swaccess: "rw"
                hwaccess: "hro"
                resval: "0"
            },
            {
                bits: "2:1"
                name: drv
                desc: '''
                     Driving strength
                '''
                swaccess: "rw"
                hwaccess: "hro"
                resval: "0"
            },
            {
                bits: "3"
                name: oen
                desc: '''
                     Output enable signal, active low
                '''
                swaccess: "rw"
                hwaccess: "hro"
                resval: "1"
            },
            {
                bits: "4"
                name: puen
                desc: '''
                     Pull-Up enable signal, active low
                '''
                swaccess: "rw"
                hwaccess: "hro"
                resval: "1"
            },
            {
                bits: "5"
                name: slw
                desc: '''
                     
                '''
                swaccess: "rw"
                hwaccess: "hro"
                resval: "0"
            },
            {
                bits: "6"
                name: smt
                desc: '''
                     Schmit trigger enable
                '''
                swaccess: "rw"
                hwaccess: "hro"
                resval: "0"
            },
          ]
      }

       {
          name: A_81_MUX_SEL
          desc: '''
              Pad signal port multiplex selection for pad a_81. The programmed value defines which port
              is connected to the pad.
          '''
          swaccess: "rw"
          hwaccess: "hro"
          resval: 0
          fields: [
              {
                  bits: "1:0"
                  enum: [
                      { value: "0", name: "register", desc: "Connects the Pad to the internal configuration register."}
                      { value: "1", name: "port_can0_can_tx", desc: "Connect port can_tx from port group can0 to this pad." }
                      { value: "2", name: "port_spi8_spi_sck", desc: "Connect port spi_sck from port group spi8 to this pad." }
                  ]
              }
          ]
      }

      {
          name: A_82_CFG
          desc: '''
            Pad signal configuration.
          '''
          swaccess: "rw"
          fields: [
            {
                bits: "0"
                name: chip2pad
                desc: '''
                     The signal that connects to the pads TX driver
                '''
                swaccess: "rw"
                hwaccess: "hro"
                resval: "0"
            },
            {
                bits: "2:1"
                name: drv
                desc: '''
                     Driving strength
                '''
                swaccess: "rw"
                hwaccess: "hro"
                resval: "0"
            },
            {
                bits: "3"
                name: oen
                desc: '''
                     Output enable signal, active low
                '''
                swaccess: "rw"
                hwaccess: "hro"
                resval: "1"
            },
            {
                bits: "4"
                name: puen
                desc: '''
                     Pull-Up enable signal, active low
                '''
                swaccess: "rw"
                hwaccess: "hro"
                resval: "1"
            },
            {
                bits: "5"
                name: slw
                desc: '''
                     
                '''
                swaccess: "rw"
                hwaccess: "hro"
                resval: "0"
            },
            {
                bits: "6"
                name: smt
                desc: '''
                     Schmit trigger enable
                '''
                swaccess: "rw"
                hwaccess: "hro"
                resval: "0"
            },
          ]
      }

       {
          name: A_82_MUX_SEL
          desc: '''
              Pad signal port multiplex selection for pad a_82. The programmed value defines which port
              is connected to the pad.
          '''
          swaccess: "rw"
          hwaccess: "hro"
          resval: 0
          fields: [
              {
                  bits: "1:0"
                  enum: [
                      { value: "0", name: "register", desc: "Connects the Pad to the internal configuration register."}
                      { value: "1", name: "port_can0_can_rx", desc: "Connect port can_rx from port group can0 to this pad." }
                      { value: "2", name: "port_spi8_spi_cs0", desc: "Connect port spi_cs0 from port group spi8 to this pad." }
                  ]
              }
          ]
      }

      {
          name: A_83_CFG
          desc: '''
            Pad signal configuration.
          '''
          swaccess: "rw"
          fields: [
            {
                bits: "0"
                name: chip2pad
                desc: '''
                     The signal that connects to the pads TX driver
                '''
                swaccess: "rw"
                hwaccess: "hro"
                resval: "0"
            },
            {
                bits: "2:1"
                name: drv
                desc: '''
                     Driving strength
                '''
                swaccess: "rw"
                hwaccess: "hro"
                resval: "0"
            },
            {
                bits: "3"
                name: oen
                desc: '''
                     Output enable signal, active low
                '''
                swaccess: "rw"
                hwaccess: "hro"
                resval: "1"
            },
            {
                bits: "4"
                name: puen
                desc: '''
                     Pull-Up enable signal, active low
                '''
                swaccess: "rw"
                hwaccess: "hro"
                resval: "1"
            },
            {
                bits: "5"
                name: slw
                desc: '''
                     
                '''
                swaccess: "rw"
                hwaccess: "hro"
                resval: "0"
            },
            {
                bits: "6"
                name: smt
                desc: '''
                     Schmit trigger enable
                '''
                swaccess: "rw"
                hwaccess: "hro"
                resval: "0"
            },
          ]
      }

       {
          name: A_83_MUX_SEL
          desc: '''
              Pad signal port multiplex selection for pad a_83. The programmed value defines which port
              is connected to the pad.
          '''
          swaccess: "rw"
          hwaccess: "hro"
          resval: 0
          fields: [
              {
                  bits: "1:0"
                  enum: [
                      { value: "0", name: "register", desc: "Connects the Pad to the internal configuration register."}
                      { value: "1", name: "port_can1_can_tx", desc: "Connect port can_tx from port group can1 to this pad." }
                      { value: "2", name: "port_spi8_spi_miso", desc: "Connect port spi_miso from port group spi8 to this pad." }
                  ]
              }
          ]
      }

      {
          name: A_84_CFG
          desc: '''
            Pad signal configuration.
          '''
          swaccess: "rw"
          fields: [
            {
                bits: "0"
                name: chip2pad
                desc: '''
                     The signal that connects to the pads TX driver
                '''
                swaccess: "rw"
                hwaccess: "hro"
                resval: "0"
            },
            {
                bits: "2:1"
                name: drv
                desc: '''
                     Driving strength
                '''
                swaccess: "rw"
                hwaccess: "hro"
                resval: "0"
            },
            {
                bits: "3"
                name: oen
                desc: '''
                     Output enable signal, active low
                '''
                swaccess: "rw"
                hwaccess: "hro"
                resval: "1"
            },
            {
                bits: "4"
                name: puen
                desc: '''
                     Pull-Up enable signal, active low
                '''
                swaccess: "rw"
                hwaccess: "hro"
                resval: "1"
            },
            {
                bits: "5"
                name: slw
                desc: '''
                     
                '''
                swaccess: "rw"
                hwaccess: "hro"
                resval: "0"
            },
            {
                bits: "6"
                name: smt
                desc: '''
                     Schmit trigger enable
                '''
                swaccess: "rw"
                hwaccess: "hro"
                resval: "0"
            },
          ]
      }

       {
          name: A_84_MUX_SEL
          desc: '''
              Pad signal port multiplex selection for pad a_84. The programmed value defines which port
              is connected to the pad.
          '''
          swaccess: "rw"
          hwaccess: "hro"
          resval: 0
          fields: [
              {
                  bits: "1:0"
                  enum: [
                      { value: "0", name: "register", desc: "Connects the Pad to the internal configuration register."}
                      { value: "1", name: "port_can1_can_rx", desc: "Connect port can_rx from port group can1 to this pad." }
                      { value: "2", name: "port_spi8_spi_mosi", desc: "Connect port spi_mosi from port group spi8 to this pad." }
                  ]
              }
          ]
      }

      {
          name: A_85_CFG
          desc: '''
            Pad signal configuration.
          '''
          swaccess: "rw"
          fields: [
            {
                bits: "0"
                name: chip2pad
                desc: '''
                     The signal that connects to the pads TX driver
                '''
                swaccess: "rw"
                hwaccess: "hro"
                resval: "0"
            },
            {
                bits: "2:1"
                name: drv
                desc: '''
                     Driving strength
                '''
                swaccess: "rw"
                hwaccess: "hro"
                resval: "0"
            },
            {
                bits: "3"
                name: oen
                desc: '''
                     Output enable signal, active low
                '''
                swaccess: "rw"
                hwaccess: "hro"
                resval: "1"
            },
            {
                bits: "4"
                name: puen
                desc: '''
                     Pull-Up enable signal, active low
                '''
                swaccess: "rw"
                hwaccess: "hro"
                resval: "1"
            },
            {
                bits: "5"
                name: slw
                desc: '''
                     
                '''
                swaccess: "rw"
                hwaccess: "hro"
                resval: "0"
            },
            {
                bits: "6"
                name: smt
                desc: '''
                     Schmit trigger enable
                '''
                swaccess: "rw"
                hwaccess: "hro"
                resval: "0"
            },
          ]
      }

       {
          name: A_85_MUX_SEL
          desc: '''
              Pad signal port multiplex selection for pad a_85. The programmed value defines which port
              is connected to the pad.
          '''
          swaccess: "rw"
          hwaccess: "hro"
          resval: 0
          fields: [
              {
                  bits: "0:0"
                  enum: [
                      { value: "0", name: "register", desc: "Connects the Pad to the internal configuration register."}
                      { value: "1", name: "port_spi9_spi_sck", desc: "Connect port spi_sck from port group spi9 to this pad." }
                  ]
              }
          ]
      }

      {
          name: A_86_CFG
          desc: '''
            Pad signal configuration.
          '''
          swaccess: "rw"
          fields: [
            {
                bits: "0"
                name: chip2pad
                desc: '''
                     The signal that connects to the pads TX driver
                '''
                swaccess: "rw"
                hwaccess: "hro"
                resval: "0"
            },
            {
                bits: "2:1"
                name: drv
                desc: '''
                     Driving strength
                '''
                swaccess: "rw"
                hwaccess: "hro"
                resval: "0"
            },
            {
                bits: "3"
                name: oen
                desc: '''
                     Output enable signal, active low
                '''
                swaccess: "rw"
                hwaccess: "hro"
                resval: "1"
            },
            {
                bits: "4"
                name: puen
                desc: '''
                     Pull-Up enable signal, active low
                '''
                swaccess: "rw"
                hwaccess: "hro"
                resval: "1"
            },
            {
                bits: "5"
                name: slw
                desc: '''
                     
                '''
                swaccess: "rw"
                hwaccess: "hro"
                resval: "0"
            },
            {
                bits: "6"
                name: smt
                desc: '''
                     Schmit trigger enable
                '''
                swaccess: "rw"
                hwaccess: "hro"
                resval: "0"
            },
          ]
      }

       {
          name: A_86_MUX_SEL
          desc: '''
              Pad signal port multiplex selection for pad a_86. The programmed value defines which port
              is connected to the pad.
          '''
          swaccess: "rw"
          hwaccess: "hro"
          resval: 0
          fields: [
              {
                  bits: "0:0"
                  enum: [
                      { value: "0", name: "register", desc: "Connects the Pad to the internal configuration register."}
                      { value: "1", name: "port_spi9_spi_cs0", desc: "Connect port spi_cs0 from port group spi9 to this pad." }
                  ]
              }
          ]
      }

      {
          name: A_87_CFG
          desc: '''
            Pad signal configuration.
          '''
          swaccess: "rw"
          fields: [
            {
                bits: "0"
                name: chip2pad
                desc: '''
                     The signal that connects to the pads TX driver
                '''
                swaccess: "rw"
                hwaccess: "hro"
                resval: "0"
            },
            {
                bits: "2:1"
                name: drv
                desc: '''
                     Driving strength
                '''
                swaccess: "rw"
                hwaccess: "hro"
                resval: "0"
            },
            {
                bits: "3"
                name: oen
                desc: '''
                     Output enable signal, active low
                '''
                swaccess: "rw"
                hwaccess: "hro"
                resval: "1"
            },
            {
                bits: "4"
                name: puen
                desc: '''
                     Pull-Up enable signal, active low
                '''
                swaccess: "rw"
                hwaccess: "hro"
                resval: "1"
            },
            {
                bits: "5"
                name: slw
                desc: '''
                     
                '''
                swaccess: "rw"
                hwaccess: "hro"
                resval: "0"
            },
            {
                bits: "6"
                name: smt
                desc: '''
                     Schmit trigger enable
                '''
                swaccess: "rw"
                hwaccess: "hro"
                resval: "0"
            },
          ]
      }

       {
          name: A_87_MUX_SEL
          desc: '''
              Pad signal port multiplex selection for pad a_87. The programmed value defines which port
              is connected to the pad.
          '''
          swaccess: "rw"
          hwaccess: "hro"
          resval: 0
          fields: [
              {
                  bits: "0:0"
                  enum: [
                      { value: "0", name: "register", desc: "Connects the Pad to the internal configuration register."}
                      { value: "1", name: "port_spi9_spi_miso", desc: "Connect port spi_miso from port group spi9 to this pad." }
                  ]
              }
          ]
      }

      {
          name: A_88_CFG
          desc: '''
            Pad signal configuration.
          '''
          swaccess: "rw"
          fields: [
            {
                bits: "0"
                name: chip2pad
                desc: '''
                     The signal that connects to the pads TX driver
                '''
                swaccess: "rw"
                hwaccess: "hro"
                resval: "0"
            },
            {
                bits: "2:1"
                name: drv
                desc: '''
                     Driving strength
                '''
                swaccess: "rw"
                hwaccess: "hro"
                resval: "0"
            },
            {
                bits: "3"
                name: oen
                desc: '''
                     Output enable signal, active low
                '''
                swaccess: "rw"
                hwaccess: "hro"
                resval: "1"
            },
            {
                bits: "4"
                name: puen
                desc: '''
                     Pull-Up enable signal, active low
                '''
                swaccess: "rw"
                hwaccess: "hro"
                resval: "1"
            },
            {
                bits: "5"
                name: slw
                desc: '''
                     
                '''
                swaccess: "rw"
                hwaccess: "hro"
                resval: "0"
            },
            {
                bits: "6"
                name: smt
                desc: '''
                     Schmit trigger enable
                '''
                swaccess: "rw"
                hwaccess: "hro"
                resval: "0"
            },
          ]
      }

       {
          name: A_88_MUX_SEL
          desc: '''
              Pad signal port multiplex selection for pad a_88. The programmed value defines which port
              is connected to the pad.
          '''
          swaccess: "rw"
          hwaccess: "hro"
          resval: 0
          fields: [
              {
                  bits: "0:0"
                  enum: [
                      { value: "0", name: "register", desc: "Connects the Pad to the internal configuration register."}
                      { value: "1", name: "port_spi9_spi_mosi", desc: "Connect port spi_mosi from port group spi9 to this pad." }
                  ]
              }
          ]
      }

      {
          name: A_89_CFG
          desc: '''
            Pad signal configuration.
          '''
          swaccess: "rw"
          fields: [
            {
                bits: "0"
                name: chip2pad
                desc: '''
                     The signal that connects to the pads TX driver
                '''
                swaccess: "rw"
                hwaccess: "hro"
                resval: "0"
            },
            {
                bits: "2:1"
                name: drv
                desc: '''
                     Driving strength
                '''
                swaccess: "rw"
                hwaccess: "hro"
                resval: "0"
            },
            {
                bits: "3"
                name: oen
                desc: '''
                     Output enable signal, active low
                '''
                swaccess: "rw"
                hwaccess: "hro"
                resval: "1"
            },
            {
                bits: "4"
                name: puen
                desc: '''
                     Pull-Up enable signal, active low
                '''
                swaccess: "rw"
                hwaccess: "hro"
                resval: "1"
            },
            {
                bits: "5"
                name: slw
                desc: '''
                     
                '''
                swaccess: "rw"
                hwaccess: "hro"
                resval: "0"
            },
            {
                bits: "6"
                name: smt
                desc: '''
                     Schmit trigger enable
                '''
                swaccess: "rw"
                hwaccess: "hro"
                resval: "0"
            },
          ]
      }

       {
          name: A_89_MUX_SEL
          desc: '''
              Pad signal port multiplex selection for pad a_89. The programmed value defines which port
              is connected to the pad.
          '''
          swaccess: "rw"
          hwaccess: "hro"
          resval: 0
          fields: [
              {
                  bits: "0:0"
                  enum: [
                      { value: "0", name: "register", desc: "Connects the Pad to the internal configuration register."}
                      { value: "1", name: "port_spi10_spi_sck", desc: "Connect port spi_sck from port group spi10 to this pad." }
                  ]
              }
          ]
      }

      {
          name: A_90_CFG
          desc: '''
            Pad signal configuration.
          '''
          swaccess: "rw"
          fields: [
            {
                bits: "0"
                name: chip2pad
                desc: '''
                     The signal that connects to the pads TX driver
                '''
                swaccess: "rw"
                hwaccess: "hro"
                resval: "0"
            },
            {
                bits: "2:1"
                name: drv
                desc: '''
                     Driving strength
                '''
                swaccess: "rw"
                hwaccess: "hro"
                resval: "0"
            },
            {
                bits: "3"
                name: oen
                desc: '''
                     Output enable signal, active low
                '''
                swaccess: "rw"
                hwaccess: "hro"
                resval: "1"
            },
            {
                bits: "4"
                name: puen
                desc: '''
                     Pull-Up enable signal, active low
                '''
                swaccess: "rw"
                hwaccess: "hro"
                resval: "1"
            },
            {
                bits: "5"
                name: slw
                desc: '''
                     
                '''
                swaccess: "rw"
                hwaccess: "hro"
                resval: "0"
            },
            {
                bits: "6"
                name: smt
                desc: '''
                     Schmit trigger enable
                '''
                swaccess: "rw"
                hwaccess: "hro"
                resval: "0"
            },
          ]
      }

       {
          name: A_90_MUX_SEL
          desc: '''
              Pad signal port multiplex selection for pad a_90. The programmed value defines which port
              is connected to the pad.
          '''
          swaccess: "rw"
          hwaccess: "hro"
          resval: 0
          fields: [
              {
                  bits: "0:0"
                  enum: [
                      { value: "0", name: "register", desc: "Connects the Pad to the internal configuration register."}
                      { value: "1", name: "port_spi10_spi_cs0", desc: "Connect port spi_cs0 from port group spi10 to this pad." }
                  ]
              }
          ]
      }

      {
          name: A_91_CFG
          desc: '''
            Pad signal configuration.
          '''
          swaccess: "rw"
          fields: [
            {
                bits: "0"
                name: chip2pad
                desc: '''
                     The signal that connects to the pads TX driver
                '''
                swaccess: "rw"
                hwaccess: "hro"
                resval: "0"
            },
            {
                bits: "2:1"
                name: drv
                desc: '''
                     Driving strength
                '''
                swaccess: "rw"
                hwaccess: "hro"
                resval: "0"
            },
            {
                bits: "3"
                name: oen
                desc: '''
                     Output enable signal, active low
                '''
                swaccess: "rw"
                hwaccess: "hro"
                resval: "1"
            },
            {
                bits: "4"
                name: puen
                desc: '''
                     Pull-Up enable signal, active low
                '''
                swaccess: "rw"
                hwaccess: "hro"
                resval: "1"
            },
            {
                bits: "5"
                name: slw
                desc: '''
                     
                '''
                swaccess: "rw"
                hwaccess: "hro"
                resval: "0"
            },
            {
                bits: "6"
                name: smt
                desc: '''
                     Schmit trigger enable
                '''
                swaccess: "rw"
                hwaccess: "hro"
                resval: "0"
            },
          ]
      }

       {
          name: A_91_MUX_SEL
          desc: '''
              Pad signal port multiplex selection for pad a_91. The programmed value defines which port
              is connected to the pad.
          '''
          swaccess: "rw"
          hwaccess: "hro"
          resval: 0
          fields: [
              {
                  bits: "0:0"
                  enum: [
                      { value: "0", name: "register", desc: "Connects the Pad to the internal configuration register."}
                      { value: "1", name: "port_spi10_spi_miso", desc: "Connect port spi_miso from port group spi10 to this pad." }
                  ]
              }
          ]
      }

      {
          name: A_92_CFG
          desc: '''
            Pad signal configuration.
          '''
          swaccess: "rw"
          fields: [
            {
                bits: "0"
                name: chip2pad
                desc: '''
                     The signal that connects to the pads TX driver
                '''
                swaccess: "rw"
                hwaccess: "hro"
                resval: "0"
            },
            {
                bits: "2:1"
                name: drv
                desc: '''
                     Driving strength
                '''
                swaccess: "rw"
                hwaccess: "hro"
                resval: "0"
            },
            {
                bits: "3"
                name: oen
                desc: '''
                     Output enable signal, active low
                '''
                swaccess: "rw"
                hwaccess: "hro"
                resval: "1"
            },
            {
                bits: "4"
                name: puen
                desc: '''
                     Pull-Up enable signal, active low
                '''
                swaccess: "rw"
                hwaccess: "hro"
                resval: "1"
            },
            {
                bits: "5"
                name: slw
                desc: '''
                     
                '''
                swaccess: "rw"
                hwaccess: "hro"
                resval: "0"
            },
            {
                bits: "6"
                name: smt
                desc: '''
                     Schmit trigger enable
                '''
                swaccess: "rw"
                hwaccess: "hro"
                resval: "0"
            },
          ]
      }

       {
          name: A_92_MUX_SEL
          desc: '''
              Pad signal port multiplex selection for pad a_92. The programmed value defines which port
              is connected to the pad.
          '''
          swaccess: "rw"
          hwaccess: "hro"
          resval: 0
          fields: [
              {
                  bits: "0:0"
                  enum: [
                      { value: "0", name: "register", desc: "Connects the Pad to the internal configuration register."}
                      { value: "1", name: "port_spi10_spi_mosi", desc: "Connect port spi_mosi from port group spi10 to this pad." }
                  ]
              }
          ]
      }

      {
          name: B_00_CFG
          desc: '''
            Pad signal configuration.
          '''
          swaccess: "rw"
          fields: [
            {
                bits: "0"
                name: chip2pad
                desc: '''
                     The signal that connects to the pads TX driver
                '''
                swaccess: "rw"
                hwaccess: "hro"
                resval: "0"
            },
            {
                bits: "2:1"
                name: drv
                desc: '''
                     Driving strength
                '''
                swaccess: "rw"
                hwaccess: "hro"
                resval: "0"
            },
            {
                bits: "3"
                name: oen
                desc: '''
                     Output enable signal, active low
                '''
                swaccess: "rw"
                hwaccess: "hro"
                resval: "1"
            },
            {
                bits: "4"
                name: puen
                desc: '''
                     Pull-Up enable signal, active low
                '''
                swaccess: "rw"
                hwaccess: "hro"
                resval: "1"
            },
            {
                bits: "5"
                name: slw
                desc: '''
                     
                '''
                swaccess: "rw"
                hwaccess: "hro"
                resval: "0"
            },
            {
                bits: "6"
                name: smt
                desc: '''
                     Schmit trigger enable
                '''
                swaccess: "rw"
                hwaccess: "hro"
                resval: "0"
            },
          ]
      }

       {
          name: B_00_MUX_SEL
          desc: '''
              Pad signal port multiplex selection for pad b_00. The programmed value defines which port
              is connected to the pad.
          '''
          swaccess: "rw"
          hwaccess: "hro"
          resval: 0
          fields: [
              {
                  bits: "0:0"
                  enum: [
                      { value: "0", name: "register", desc: "Connects the Pad to the internal configuration register."}
                      { value: "1", name: "port_gpio_b_gpio0", desc: "Connect port gpio0 from port group gpio_b to this pad." }
                  ]
              }
          ]
      }

      {
          name: B_01_CFG
          desc: '''
            Pad signal configuration.
          '''
          swaccess: "rw"
          fields: [
            {
                bits: "0"
                name: chip2pad
                desc: '''
                     The signal that connects to the pads TX driver
                '''
                swaccess: "rw"
                hwaccess: "hro"
                resval: "0"
            },
            {
                bits: "2:1"
                name: drv
                desc: '''
                     Driving strength
                '''
                swaccess: "rw"
                hwaccess: "hro"
                resval: "0"
            },
            {
                bits: "3"
                name: oen
                desc: '''
                     Output enable signal, active low
                '''
                swaccess: "rw"
                hwaccess: "hro"
                resval: "1"
            },
            {
                bits: "4"
                name: puen
                desc: '''
                     Pull-Up enable signal, active low
                '''
                swaccess: "rw"
                hwaccess: "hro"
                resval: "1"
            },
            {
                bits: "5"
                name: slw
                desc: '''
                     
                '''
                swaccess: "rw"
                hwaccess: "hro"
                resval: "0"
            },
            {
                bits: "6"
                name: smt
                desc: '''
                     Schmit trigger enable
                '''
                swaccess: "rw"
                hwaccess: "hro"
                resval: "0"
            },
          ]
      }

       {
          name: B_01_MUX_SEL
          desc: '''
              Pad signal port multiplex selection for pad b_01. The programmed value defines which port
              is connected to the pad.
          '''
          swaccess: "rw"
          hwaccess: "hro"
          resval: 0
          fields: [
              {
                  bits: "0:0"
                  enum: [
                      { value: "0", name: "register", desc: "Connects the Pad to the internal configuration register."}
                      { value: "1", name: "port_gpio_b_gpio1", desc: "Connect port gpio1 from port group gpio_b to this pad." }
                  ]
              }
          ]
      }

      {
          name: B_02_CFG
          desc: '''
            Pad signal configuration.
          '''
          swaccess: "rw"
          fields: [
            {
                bits: "0"
                name: chip2pad
                desc: '''
                     The signal that connects to the pads TX driver
                '''
                swaccess: "rw"
                hwaccess: "hro"
                resval: "0"
            },
            {
                bits: "2:1"
                name: drv
                desc: '''
                     Driving strength
                '''
                swaccess: "rw"
                hwaccess: "hro"
                resval: "0"
            },
            {
                bits: "3"
                name: oen
                desc: '''
                     Output enable signal, active low
                '''
                swaccess: "rw"
                hwaccess: "hro"
                resval: "1"
            },
            {
                bits: "4"
                name: puen
                desc: '''
                     Pull-Up enable signal, active low
                '''
                swaccess: "rw"
                hwaccess: "hro"
                resval: "1"
            },
            {
                bits: "5"
                name: slw
                desc: '''
                     
                '''
                swaccess: "rw"
                hwaccess: "hro"
                resval: "0"
            },
            {
                bits: "6"
                name: smt
                desc: '''
                     Schmit trigger enable
                '''
                swaccess: "rw"
                hwaccess: "hro"
                resval: "0"
            },
          ]
      }

       {
          name: B_02_MUX_SEL
          desc: '''
              Pad signal port multiplex selection for pad b_02. The programmed value defines which port
              is connected to the pad.
          '''
          swaccess: "rw"
          hwaccess: "hro"
          resval: 0
          fields: [
              {
                  bits: "0:0"
                  enum: [
                      { value: "0", name: "register", desc: "Connects the Pad to the internal configuration register."}
                      { value: "1", name: "port_gpio_b_gpio2", desc: "Connect port gpio2 from port group gpio_b to this pad." }
                  ]
              }
          ]
      }

      {
          name: B_03_CFG
          desc: '''
            Pad signal configuration.
          '''
          swaccess: "rw"
          fields: [
            {
                bits: "0"
                name: chip2pad
                desc: '''
                     The signal that connects to the pads TX driver
                '''
                swaccess: "rw"
                hwaccess: "hro"
                resval: "0"
            },
            {
                bits: "2:1"
                name: drv
                desc: '''
                     Driving strength
                '''
                swaccess: "rw"
                hwaccess: "hro"
                resval: "0"
            },
            {
                bits: "3"
                name: oen
                desc: '''
                     Output enable signal, active low
                '''
                swaccess: "rw"
                hwaccess: "hro"
                resval: "1"
            },
            {
                bits: "4"
                name: puen
                desc: '''
                     Pull-Up enable signal, active low
                '''
                swaccess: "rw"
                hwaccess: "hro"
                resval: "1"
            },
            {
                bits: "5"
                name: slw
                desc: '''
                     
                '''
                swaccess: "rw"
                hwaccess: "hro"
                resval: "0"
            },
            {
                bits: "6"
                name: smt
                desc: '''
                     Schmit trigger enable
                '''
                swaccess: "rw"
                hwaccess: "hro"
                resval: "0"
            },
          ]
      }

       {
          name: B_03_MUX_SEL
          desc: '''
              Pad signal port multiplex selection for pad b_03. The programmed value defines which port
              is connected to the pad.
          '''
          swaccess: "rw"
          hwaccess: "hro"
          resval: 0
          fields: [
              {
                  bits: "0:0"
                  enum: [
                      { value: "0", name: "register", desc: "Connects the Pad to the internal configuration register."}
                      { value: "1", name: "port_gpio_b_gpio3", desc: "Connect port gpio3 from port group gpio_b to this pad." }
                  ]
              }
          ]
      }

      {
          name: B_04_CFG
          desc: '''
            Pad signal configuration.
          '''
          swaccess: "rw"
          fields: [
            {
                bits: "0"
                name: chip2pad
                desc: '''
                     The signal that connects to the pads TX driver
                '''
                swaccess: "rw"
                hwaccess: "hro"
                resval: "0"
            },
            {
                bits: "2:1"
                name: drv
                desc: '''
                     Driving strength
                '''
                swaccess: "rw"
                hwaccess: "hro"
                resval: "0"
            },
            {
                bits: "3"
                name: oen
                desc: '''
                     Output enable signal, active low
                '''
                swaccess: "rw"
                hwaccess: "hro"
                resval: "1"
            },
            {
                bits: "4"
                name: puen
                desc: '''
                     Pull-Up enable signal, active low
                '''
                swaccess: "rw"
                hwaccess: "hro"
                resval: "1"
            },
            {
                bits: "5"
                name: slw
                desc: '''
                     
                '''
                swaccess: "rw"
                hwaccess: "hro"
                resval: "0"
            },
            {
                bits: "6"
                name: smt
                desc: '''
                     Schmit trigger enable
                '''
                swaccess: "rw"
                hwaccess: "hro"
                resval: "0"
            },
          ]
      }

       {
          name: B_04_MUX_SEL
          desc: '''
              Pad signal port multiplex selection for pad b_04. The programmed value defines which port
              is connected to the pad.
          '''
          swaccess: "rw"
          hwaccess: "hro"
          resval: 0
          fields: [
              {
                  bits: "0:0"
                  enum: [
                      { value: "0", name: "register", desc: "Connects the Pad to the internal configuration register."}
                      { value: "1", name: "port_gpio_b_gpio4", desc: "Connect port gpio4 from port group gpio_b to this pad." }
                  ]
              }
          ]
      }

      {
          name: B_05_CFG
          desc: '''
            Pad signal configuration.
          '''
          swaccess: "rw"
          fields: [
            {
                bits: "0"
                name: chip2pad
                desc: '''
                     The signal that connects to the pads TX driver
                '''
                swaccess: "rw"
                hwaccess: "hro"
                resval: "0"
            },
            {
                bits: "2:1"
                name: drv
                desc: '''
                     Driving strength
                '''
                swaccess: "rw"
                hwaccess: "hro"
                resval: "0"
            },
            {
                bits: "3"
                name: oen
                desc: '''
                     Output enable signal, active low
                '''
                swaccess: "rw"
                hwaccess: "hro"
                resval: "1"
            },
            {
                bits: "4"
                name: puen
                desc: '''
                     Pull-Up enable signal, active low
                '''
                swaccess: "rw"
                hwaccess: "hro"
                resval: "1"
            },
            {
                bits: "5"
                name: slw
                desc: '''
                     
                '''
                swaccess: "rw"
                hwaccess: "hro"
                resval: "0"
            },
            {
                bits: "6"
                name: smt
                desc: '''
                     Schmit trigger enable
                '''
                swaccess: "rw"
                hwaccess: "hro"
                resval: "0"
            },
          ]
      }

       {
          name: B_05_MUX_SEL
          desc: '''
              Pad signal port multiplex selection for pad b_05. The programmed value defines which port
              is connected to the pad.
          '''
          swaccess: "rw"
          hwaccess: "hro"
          resval: 0
          fields: [
              {
                  bits: "0:0"
                  enum: [
                      { value: "0", name: "register", desc: "Connects the Pad to the internal configuration register."}
                      { value: "1", name: "port_gpio_b_gpio5", desc: "Connect port gpio5 from port group gpio_b to this pad." }
                  ]
              }
          ]
      }

      {
          name: B_06_CFG
          desc: '''
            Pad signal configuration.
          '''
          swaccess: "rw"
          fields: [
            {
                bits: "0"
                name: chip2pad
                desc: '''
                     The signal that connects to the pads TX driver
                '''
                swaccess: "rw"
                hwaccess: "hro"
                resval: "0"
            },
            {
                bits: "2:1"
                name: drv
                desc: '''
                     Driving strength
                '''
                swaccess: "rw"
                hwaccess: "hro"
                resval: "0"
            },
            {
                bits: "3"
                name: oen
                desc: '''
                     Output enable signal, active low
                '''
                swaccess: "rw"
                hwaccess: "hro"
                resval: "1"
            },
            {
                bits: "4"
                name: puen
                desc: '''
                     Pull-Up enable signal, active low
                '''
                swaccess: "rw"
                hwaccess: "hro"
                resval: "1"
            },
            {
                bits: "5"
                name: slw
                desc: '''
                     
                '''
                swaccess: "rw"
                hwaccess: "hro"
                resval: "0"
            },
            {
                bits: "6"
                name: smt
                desc: '''
                     Schmit trigger enable
                '''
                swaccess: "rw"
                hwaccess: "hro"
                resval: "0"
            },
          ]
      }

       {
          name: B_06_MUX_SEL
          desc: '''
              Pad signal port multiplex selection for pad b_06. The programmed value defines which port
              is connected to the pad.
          '''
          swaccess: "rw"
          hwaccess: "hro"
          resval: 0
          fields: [
              {
                  bits: "0:0"
                  enum: [
                      { value: "0", name: "register", desc: "Connects the Pad to the internal configuration register."}
                      { value: "1", name: "port_gpio_b_gpio6", desc: "Connect port gpio6 from port group gpio_b to this pad." }
                  ]
              }
          ]
      }

      {
          name: B_07_CFG
          desc: '''
            Pad signal configuration.
          '''
          swaccess: "rw"
          fields: [
            {
                bits: "0"
                name: chip2pad
                desc: '''
                     The signal that connects to the pads TX driver
                '''
                swaccess: "rw"
                hwaccess: "hro"
                resval: "0"
            },
            {
                bits: "2:1"
                name: drv
                desc: '''
                     Driving strength
                '''
                swaccess: "rw"
                hwaccess: "hro"
                resval: "0"
            },
            {
                bits: "3"
                name: oen
                desc: '''
                     Output enable signal, active low
                '''
                swaccess: "rw"
                hwaccess: "hro"
                resval: "1"
            },
            {
                bits: "4"
                name: puen
                desc: '''
                     Pull-Up enable signal, active low
                '''
                swaccess: "rw"
                hwaccess: "hro"
                resval: "1"
            },
            {
                bits: "5"
                name: slw
                desc: '''
                     
                '''
                swaccess: "rw"
                hwaccess: "hro"
                resval: "0"
            },
            {
                bits: "6"
                name: smt
                desc: '''
                     Schmit trigger enable
                '''
                swaccess: "rw"
                hwaccess: "hro"
                resval: "0"
            },
          ]
      }

       {
          name: B_07_MUX_SEL
          desc: '''
              Pad signal port multiplex selection for pad b_07. The programmed value defines which port
              is connected to the pad.
          '''
          swaccess: "rw"
          hwaccess: "hro"
          resval: 0
          fields: [
              {
                  bits: "0:0"
                  enum: [
                      { value: "0", name: "register", desc: "Connects the Pad to the internal configuration register."}
                      { value: "1", name: "port_gpio_b_gpio7", desc: "Connect port gpio7 from port group gpio_b to this pad." }
                  ]
              }
          ]
      }

      {
          name: B_08_CFG
          desc: '''
            Pad signal configuration.
          '''
          swaccess: "rw"
          fields: [
            {
                bits: "0"
                name: chip2pad
                desc: '''
                     The signal that connects to the pads TX driver
                '''
                swaccess: "rw"
                hwaccess: "hro"
                resval: "0"
            },
            {
                bits: "2:1"
                name: drv
                desc: '''
                     Driving strength
                '''
                swaccess: "rw"
                hwaccess: "hro"
                resval: "0"
            },
            {
                bits: "3"
                name: oen
                desc: '''
                     Output enable signal, active low
                '''
                swaccess: "rw"
                hwaccess: "hro"
                resval: "1"
            },
            {
                bits: "4"
                name: puen
                desc: '''
                     Pull-Up enable signal, active low
                '''
                swaccess: "rw"
                hwaccess: "hro"
                resval: "1"
            },
            {
                bits: "5"
                name: slw
                desc: '''
                     
                '''
                swaccess: "rw"
                hwaccess: "hro"
                resval: "0"
            },
            {
                bits: "6"
                name: smt
                desc: '''
                     Schmit trigger enable
                '''
                swaccess: "rw"
                hwaccess: "hro"
                resval: "0"
            },
          ]
      }

       {
          name: B_08_MUX_SEL
          desc: '''
              Pad signal port multiplex selection for pad b_08. The programmed value defines which port
              is connected to the pad.
          '''
          swaccess: "rw"
          hwaccess: "hro"
          resval: 0
          fields: [
              {
                  bits: "0:0"
                  enum: [
                      { value: "0", name: "register", desc: "Connects the Pad to the internal configuration register."}
                      { value: "1", name: "port_gpio_b_gpio8", desc: "Connect port gpio8 from port group gpio_b to this pad." }
                  ]
              }
          ]
      }

      {
          name: B_09_CFG
          desc: '''
            Pad signal configuration.
          '''
          swaccess: "rw"
          fields: [
            {
                bits: "0"
                name: chip2pad
                desc: '''
                     The signal that connects to the pads TX driver
                '''
                swaccess: "rw"
                hwaccess: "hro"
                resval: "0"
            },
            {
                bits: "2:1"
                name: drv
                desc: '''
                     Driving strength
                '''
                swaccess: "rw"
                hwaccess: "hro"
                resval: "0"
            },
            {
                bits: "3"
                name: oen
                desc: '''
                     Output enable signal, active low
                '''
                swaccess: "rw"
                hwaccess: "hro"
                resval: "1"
            },
            {
                bits: "4"
                name: puen
                desc: '''
                     Pull-Up enable signal, active low
                '''
                swaccess: "rw"
                hwaccess: "hro"
                resval: "1"
            },
            {
                bits: "5"
                name: slw
                desc: '''
                     
                '''
                swaccess: "rw"
                hwaccess: "hro"
                resval: "0"
            },
            {
                bits: "6"
                name: smt
                desc: '''
                     Schmit trigger enable
                '''
                swaccess: "rw"
                hwaccess: "hro"
                resval: "0"
            },
          ]
      }

       {
          name: B_09_MUX_SEL
          desc: '''
              Pad signal port multiplex selection for pad b_09. The programmed value defines which port
              is connected to the pad.
          '''
          swaccess: "rw"
          hwaccess: "hro"
          resval: 0
          fields: [
              {
                  bits: "0:0"
                  enum: [
                      { value: "0", name: "register", desc: "Connects the Pad to the internal configuration register."}
                      { value: "1", name: "port_gpio_b_gpio9", desc: "Connect port gpio9 from port group gpio_b to this pad." }
                  ]
              }
          ]
      }

      {
          name: B_10_CFG
          desc: '''
            Pad signal configuration.
          '''
          swaccess: "rw"
          fields: [
            {
                bits: "0"
                name: chip2pad
                desc: '''
                     The signal that connects to the pads TX driver
                '''
                swaccess: "rw"
                hwaccess: "hro"
                resval: "0"
            },
            {
                bits: "2:1"
                name: drv
                desc: '''
                     Driving strength
                '''
                swaccess: "rw"
                hwaccess: "hro"
                resval: "0"
            },
            {
                bits: "3"
                name: oen
                desc: '''
                     Output enable signal, active low
                '''
                swaccess: "rw"
                hwaccess: "hro"
                resval: "1"
            },
            {
                bits: "4"
                name: puen
                desc: '''
                     Pull-Up enable signal, active low
                '''
                swaccess: "rw"
                hwaccess: "hro"
                resval: "1"
            },
            {
                bits: "5"
                name: slw
                desc: '''
                     
                '''
                swaccess: "rw"
                hwaccess: "hro"
                resval: "0"
            },
            {
                bits: "6"
                name: smt
                desc: '''
                     Schmit trigger enable
                '''
                swaccess: "rw"
                hwaccess: "hro"
                resval: "0"
            },
          ]
      }

       {
          name: B_10_MUX_SEL
          desc: '''
              Pad signal port multiplex selection for pad b_10. The programmed value defines which port
              is connected to the pad.
          '''
          swaccess: "rw"
          hwaccess: "hro"
          resval: 0
          fields: [
              {
                  bits: "0:0"
                  enum: [
                      { value: "0", name: "register", desc: "Connects the Pad to the internal configuration register."}
                      { value: "1", name: "port_gpio_b_gpio10", desc: "Connect port gpio10 from port group gpio_b to this pad." }
                  ]
              }
          ]
      }

      {
          name: B_11_CFG
          desc: '''
            Pad signal configuration.
          '''
          swaccess: "rw"
          fields: [
            {
                bits: "0"
                name: chip2pad
                desc: '''
                     The signal that connects to the pads TX driver
                '''
                swaccess: "rw"
                hwaccess: "hro"
                resval: "0"
            },
            {
                bits: "2:1"
                name: drv
                desc: '''
                     Driving strength
                '''
                swaccess: "rw"
                hwaccess: "hro"
                resval: "0"
            },
            {
                bits: "3"
                name: oen
                desc: '''
                     Output enable signal, active low
                '''
                swaccess: "rw"
                hwaccess: "hro"
                resval: "1"
            },
            {
                bits: "4"
                name: puen
                desc: '''
                     Pull-Up enable signal, active low
                '''
                swaccess: "rw"
                hwaccess: "hro"
                resval: "1"
            },
            {
                bits: "5"
                name: slw
                desc: '''
                     
                '''
                swaccess: "rw"
                hwaccess: "hro"
                resval: "0"
            },
            {
                bits: "6"
                name: smt
                desc: '''
                     Schmit trigger enable
                '''
                swaccess: "rw"
                hwaccess: "hro"
                resval: "0"
            },
          ]
      }

       {
          name: B_11_MUX_SEL
          desc: '''
              Pad signal port multiplex selection for pad b_11. The programmed value defines which port
              is connected to the pad.
          '''
          swaccess: "rw"
          hwaccess: "hro"
          resval: 0
          fields: [
              {
                  bits: "0:0"
                  enum: [
                      { value: "0", name: "register", desc: "Connects the Pad to the internal configuration register."}
                      { value: "1", name: "port_gpio_b_gpio11", desc: "Connect port gpio11 from port group gpio_b to this pad." }
                  ]
              }
          ]
      }

      {
          name: B_12_CFG
          desc: '''
            Pad signal configuration.
          '''
          swaccess: "rw"
          fields: [
            {
                bits: "0"
                name: chip2pad
                desc: '''
                     The signal that connects to the pads TX driver
                '''
                swaccess: "rw"
                hwaccess: "hro"
                resval: "0"
            },
            {
                bits: "2:1"
                name: drv
                desc: '''
                     Driving strength
                '''
                swaccess: "rw"
                hwaccess: "hro"
                resval: "0"
            },
            {
                bits: "3"
                name: oen
                desc: '''
                     Output enable signal, active low
                '''
                swaccess: "rw"
                hwaccess: "hro"
                resval: "1"
            },
            {
                bits: "4"
                name: puen
                desc: '''
                     Pull-Up enable signal, active low
                '''
                swaccess: "rw"
                hwaccess: "hro"
                resval: "1"
            },
            {
                bits: "5"
                name: slw
                desc: '''
                     
                '''
                swaccess: "rw"
                hwaccess: "hro"
                resval: "0"
            },
            {
                bits: "6"
                name: smt
                desc: '''
                     Schmit trigger enable
                '''
                swaccess: "rw"
                hwaccess: "hro"
                resval: "0"
            },
          ]
      }

       {
          name: B_12_MUX_SEL
          desc: '''
              Pad signal port multiplex selection for pad b_12. The programmed value defines which port
              is connected to the pad.
          '''
          swaccess: "rw"
          hwaccess: "hro"
          resval: 0
          fields: [
              {
                  bits: "0:0"
                  enum: [
                      { value: "0", name: "register", desc: "Connects the Pad to the internal configuration register."}
                      { value: "1", name: "port_gpio_b_gpio12", desc: "Connect port gpio12 from port group gpio_b to this pad." }
                  ]
              }
          ]
      }

      {
          name: B_13_CFG
          desc: '''
            Pad signal configuration.
          '''
          swaccess: "rw"
          fields: [
            {
                bits: "0"
                name: chip2pad
                desc: '''
                     The signal that connects to the pads TX driver
                '''
                swaccess: "rw"
                hwaccess: "hro"
                resval: "0"
            },
            {
                bits: "2:1"
                name: drv
                desc: '''
                     Driving strength
                '''
                swaccess: "rw"
                hwaccess: "hro"
                resval: "0"
            },
            {
                bits: "3"
                name: oen
                desc: '''
                     Output enable signal, active low
                '''
                swaccess: "rw"
                hwaccess: "hro"
                resval: "1"
            },
            {
                bits: "4"
                name: puen
                desc: '''
                     Pull-Up enable signal, active low
                '''
                swaccess: "rw"
                hwaccess: "hro"
                resval: "1"
            },
            {
                bits: "5"
                name: slw
                desc: '''
                     
                '''
                swaccess: "rw"
                hwaccess: "hro"
                resval: "0"
            },
            {
                bits: "6"
                name: smt
                desc: '''
                     Schmit trigger enable
                '''
                swaccess: "rw"
                hwaccess: "hro"
                resval: "0"
            },
          ]
      }

       {
          name: B_13_MUX_SEL
          desc: '''
              Pad signal port multiplex selection for pad b_13. The programmed value defines which port
              is connected to the pad.
          '''
          swaccess: "rw"
          hwaccess: "hro"
          resval: 0
          fields: [
              {
                  bits: "0:0"
                  enum: [
                      { value: "0", name: "register", desc: "Connects the Pad to the internal configuration register."}
                      { value: "1", name: "port_gpio_b_gpio13", desc: "Connect port gpio13 from port group gpio_b to this pad." }
                  ]
              }
          ]
      }

      {
          name: B_14_CFG
          desc: '''
            Pad signal configuration.
          '''
          swaccess: "rw"
          fields: [
            {
                bits: "0"
                name: chip2pad
                desc: '''
                     The signal that connects to the pads TX driver
                '''
                swaccess: "rw"
                hwaccess: "hro"
                resval: "0"
            },
            {
                bits: "2:1"
                name: drv
                desc: '''
                     Driving strength
                '''
                swaccess: "rw"
                hwaccess: "hro"
                resval: "0"
            },
            {
                bits: "3"
                name: oen
                desc: '''
                     Output enable signal, active low
                '''
                swaccess: "rw"
                hwaccess: "hro"
                resval: "1"
            },
            {
                bits: "4"
                name: puen
                desc: '''
                     Pull-Up enable signal, active low
                '''
                swaccess: "rw"
                hwaccess: "hro"
                resval: "1"
            },
            {
                bits: "5"
                name: slw
                desc: '''
                     
                '''
                swaccess: "rw"
                hwaccess: "hro"
                resval: "0"
            },
            {
                bits: "6"
                name: smt
                desc: '''
                     Schmit trigger enable
                '''
                swaccess: "rw"
                hwaccess: "hro"
                resval: "0"
            },
          ]
      }

       {
          name: B_14_MUX_SEL
          desc: '''
              Pad signal port multiplex selection for pad b_14. The programmed value defines which port
              is connected to the pad.
          '''
          swaccess: "rw"
          hwaccess: "hro"
          resval: 0
          fields: [
              {
                  bits: "0:0"
                  enum: [
                      { value: "0", name: "register", desc: "Connects the Pad to the internal configuration register."}
                      { value: "1", name: "port_gpio_b_gpio14", desc: "Connect port gpio14 from port group gpio_b to this pad." }
                  ]
              }
          ]
      }

      {
          name: B_15_CFG
          desc: '''
            Pad signal configuration.
          '''
          swaccess: "rw"
          fields: [
            {
                bits: "0"
                name: chip2pad
                desc: '''
                     The signal that connects to the pads TX driver
                '''
                swaccess: "rw"
                hwaccess: "hro"
                resval: "0"
            },
            {
                bits: "2:1"
                name: drv
                desc: '''
                     Driving strength
                '''
                swaccess: "rw"
                hwaccess: "hro"
                resval: "0"
            },
            {
                bits: "3"
                name: oen
                desc: '''
                     Output enable signal, active low
                '''
                swaccess: "rw"
                hwaccess: "hro"
                resval: "1"
            },
            {
                bits: "4"
                name: puen
                desc: '''
                     Pull-Up enable signal, active low
                '''
                swaccess: "rw"
                hwaccess: "hro"
                resval: "1"
            },
            {
                bits: "5"
                name: slw
                desc: '''
                     
                '''
                swaccess: "rw"
                hwaccess: "hro"
                resval: "0"
            },
            {
                bits: "6"
                name: smt
                desc: '''
                     Schmit trigger enable
                '''
                swaccess: "rw"
                hwaccess: "hro"
                resval: "0"
            },
          ]
      }

       {
          name: B_15_MUX_SEL
          desc: '''
              Pad signal port multiplex selection for pad b_15. The programmed value defines which port
              is connected to the pad.
          '''
          swaccess: "rw"
          hwaccess: "hro"
          resval: 0
          fields: [
              {
                  bits: "0:0"
                  enum: [
                      { value: "0", name: "register", desc: "Connects the Pad to the internal configuration register."}
                      { value: "1", name: "port_gpio_b_gpio15", desc: "Connect port gpio15 from port group gpio_b to this pad." }
                  ]
              }
          ]
      }

      {
          name: B_16_CFG
          desc: '''
            Pad signal configuration.
          '''
          swaccess: "rw"
          fields: [
            {
                bits: "0"
                name: chip2pad
                desc: '''
                     The signal that connects to the pads TX driver
                '''
                swaccess: "rw"
                hwaccess: "hro"
                resval: "0"
            },
            {
                bits: "2:1"
                name: drv
                desc: '''
                     Driving strength
                '''
                swaccess: "rw"
                hwaccess: "hro"
                resval: "0"
            },
            {
                bits: "3"
                name: oen
                desc: '''
                     Output enable signal, active low
                '''
                swaccess: "rw"
                hwaccess: "hro"
                resval: "1"
            },
            {
                bits: "4"
                name: puen
                desc: '''
                     Pull-Up enable signal, active low
                '''
                swaccess: "rw"
                hwaccess: "hro"
                resval: "1"
            },
            {
                bits: "5"
                name: slw
                desc: '''
                     
                '''
                swaccess: "rw"
                hwaccess: "hro"
                resval: "0"
            },
            {
                bits: "6"
                name: smt
                desc: '''
                     Schmit trigger enable
                '''
                swaccess: "rw"
                hwaccess: "hro"
                resval: "0"
            },
          ]
      }

       {
          name: B_16_MUX_SEL
          desc: '''
              Pad signal port multiplex selection for pad b_16. The programmed value defines which port
              is connected to the pad.
          '''
          swaccess: "rw"
          hwaccess: "hro"
          resval: 0
          fields: [
              {
                  bits: "0:0"
                  enum: [
                      { value: "0", name: "register", desc: "Connects the Pad to the internal configuration register."}
                      { value: "1", name: "port_gpio_b_gpio16", desc: "Connect port gpio16 from port group gpio_b to this pad." }
                  ]
              }
          ]
      }

      {
          name: B_17_CFG
          desc: '''
            Pad signal configuration.
          '''
          swaccess: "rw"
          fields: [
            {
                bits: "0"
                name: chip2pad
                desc: '''
                     The signal that connects to the pads TX driver
                '''
                swaccess: "rw"
                hwaccess: "hro"
                resval: "0"
            },
            {
                bits: "2:1"
                name: drv
                desc: '''
                     Driving strength
                '''
                swaccess: "rw"
                hwaccess: "hro"
                resval: "0"
            },
            {
                bits: "3"
                name: oen
                desc: '''
                     Output enable signal, active low
                '''
                swaccess: "rw"
                hwaccess: "hro"
                resval: "1"
            },
            {
                bits: "4"
                name: puen
                desc: '''
                     Pull-Up enable signal, active low
                '''
                swaccess: "rw"
                hwaccess: "hro"
                resval: "1"
            },
            {
                bits: "5"
                name: slw
                desc: '''
                     
                '''
                swaccess: "rw"
                hwaccess: "hro"
                resval: "0"
            },
            {
                bits: "6"
                name: smt
                desc: '''
                     Schmit trigger enable
                '''
                swaccess: "rw"
                hwaccess: "hro"
                resval: "0"
            },
          ]
      }

       {
          name: B_17_MUX_SEL
          desc: '''
              Pad signal port multiplex selection for pad b_17. The programmed value defines which port
              is connected to the pad.
          '''
          swaccess: "rw"
          hwaccess: "hro"
          resval: 0
          fields: [
              {
                  bits: "0:0"
                  enum: [
                      { value: "0", name: "register", desc: "Connects the Pad to the internal configuration register."}
                      { value: "1", name: "port_gpio_b_gpio17", desc: "Connect port gpio17 from port group gpio_b to this pad." }
                  ]
              }
          ]
      }

      {
          name: B_18_CFG
          desc: '''
            Pad signal configuration.
          '''
          swaccess: "rw"
          fields: [
            {
                bits: "0"
                name: chip2pad
                desc: '''
                     The signal that connects to the pads TX driver
                '''
                swaccess: "rw"
                hwaccess: "hro"
                resval: "0"
            },
            {
                bits: "2:1"
                name: drv
                desc: '''
                     Driving strength
                '''
                swaccess: "rw"
                hwaccess: "hro"
                resval: "0"
            },
            {
                bits: "3"
                name: oen
                desc: '''
                     Output enable signal, active low
                '''
                swaccess: "rw"
                hwaccess: "hro"
                resval: "1"
            },
            {
                bits: "4"
                name: puen
                desc: '''
                     Pull-Up enable signal, active low
                '''
                swaccess: "rw"
                hwaccess: "hro"
                resval: "1"
            },
            {
                bits: "5"
                name: slw
                desc: '''
                     
                '''
                swaccess: "rw"
                hwaccess: "hro"
                resval: "0"
            },
            {
                bits: "6"
                name: smt
                desc: '''
                     Schmit trigger enable
                '''
                swaccess: "rw"
                hwaccess: "hro"
                resval: "0"
            },
          ]
      }

       {
          name: B_18_MUX_SEL
          desc: '''
              Pad signal port multiplex selection for pad b_18. The programmed value defines which port
              is connected to the pad.
          '''
          swaccess: "rw"
          hwaccess: "hro"
          resval: 0
          fields: [
              {
                  bits: "0:0"
                  enum: [
                      { value: "0", name: "register", desc: "Connects the Pad to the internal configuration register."}
                      { value: "1", name: "port_gpio_b_gpio18", desc: "Connect port gpio18 from port group gpio_b to this pad." }
                  ]
              }
          ]
      }

      {
          name: B_19_CFG
          desc: '''
            Pad signal configuration.
          '''
          swaccess: "rw"
          fields: [
            {
                bits: "0"
                name: chip2pad
                desc: '''
                     The signal that connects to the pads TX driver
                '''
                swaccess: "rw"
                hwaccess: "hro"
                resval: "0"
            },
            {
                bits: "2:1"
                name: drv
                desc: '''
                     Driving strength
                '''
                swaccess: "rw"
                hwaccess: "hro"
                resval: "0"
            },
            {
                bits: "3"
                name: oen
                desc: '''
                     Output enable signal, active low
                '''
                swaccess: "rw"
                hwaccess: "hro"
                resval: "1"
            },
            {
                bits: "4"
                name: puen
                desc: '''
                     Pull-Up enable signal, active low
                '''
                swaccess: "rw"
                hwaccess: "hro"
                resval: "1"
            },
            {
                bits: "5"
                name: slw
                desc: '''
                     
                '''
                swaccess: "rw"
                hwaccess: "hro"
                resval: "0"
            },
            {
                bits: "6"
                name: smt
                desc: '''
                     Schmit trigger enable
                '''
                swaccess: "rw"
                hwaccess: "hro"
                resval: "0"
            },
          ]
      }

       {
          name: B_19_MUX_SEL
          desc: '''
              Pad signal port multiplex selection for pad b_19. The programmed value defines which port
              is connected to the pad.
          '''
          swaccess: "rw"
          hwaccess: "hro"
          resval: 0
          fields: [
              {
                  bits: "1:0"
                  enum: [
                      { value: "0", name: "register", desc: "Connects the Pad to the internal configuration register."}
                      { value: "1", name: "port_cam0_cam_hsync", desc: "Connect port cam_hsync from port group cam0 to this pad." }
                      { value: "2", name: "port_gpio_b_gpio19", desc: "Connect port gpio19 from port group gpio_b to this pad." }
                  ]
              }
          ]
      }

      {
          name: B_20_CFG
          desc: '''
            Pad signal configuration.
          '''
          swaccess: "rw"
          fields: [
            {
                bits: "0"
                name: chip2pad
                desc: '''
                     The signal that connects to the pads TX driver
                '''
                swaccess: "rw"
                hwaccess: "hro"
                resval: "0"
            },
            {
                bits: "2:1"
                name: drv
                desc: '''
                     Driving strength
                '''
                swaccess: "rw"
                hwaccess: "hro"
                resval: "0"
            },
            {
                bits: "3"
                name: oen
                desc: '''
                     Output enable signal, active low
                '''
                swaccess: "rw"
                hwaccess: "hro"
                resval: "1"
            },
            {
                bits: "4"
                name: puen
                desc: '''
                     Pull-Up enable signal, active low
                '''
                swaccess: "rw"
                hwaccess: "hro"
                resval: "1"
            },
            {
                bits: "5"
                name: slw
                desc: '''
                     
                '''
                swaccess: "rw"
                hwaccess: "hro"
                resval: "0"
            },
            {
                bits: "6"
                name: smt
                desc: '''
                     Schmit trigger enable
                '''
                swaccess: "rw"
                hwaccess: "hro"
                resval: "0"
            },
          ]
      }

       {
          name: B_20_MUX_SEL
          desc: '''
              Pad signal port multiplex selection for pad b_20. The programmed value defines which port
              is connected to the pad.
          '''
          swaccess: "rw"
          hwaccess: "hro"
          resval: 0
          fields: [
              {
                  bits: "1:0"
                  enum: [
                      { value: "0", name: "register", desc: "Connects the Pad to the internal configuration register."}
                      { value: "1", name: "port_cam0_cam_data4_i", desc: "Connect port cam_data4_i from port group cam0 to this pad." }
                      { value: "2", name: "port_gpio_b_gpio20", desc: "Connect port gpio20 from port group gpio_b to this pad." }
                  ]
              }
          ]
      }

      {
          name: B_21_CFG
          desc: '''
            Pad signal configuration.
          '''
          swaccess: "rw"
          fields: [
            {
                bits: "0"
                name: chip2pad
                desc: '''
                     The signal that connects to the pads TX driver
                '''
                swaccess: "rw"
                hwaccess: "hro"
                resval: "0"
            },
            {
                bits: "2:1"
                name: drv
                desc: '''
                     Driving strength
                '''
                swaccess: "rw"
                hwaccess: "hro"
                resval: "0"
            },
            {
                bits: "3"
                name: oen
                desc: '''
                     Output enable signal, active low
                '''
                swaccess: "rw"
                hwaccess: "hro"
                resval: "1"
            },
            {
                bits: "4"
                name: puen
                desc: '''
                     Pull-Up enable signal, active low
                '''
                swaccess: "rw"
                hwaccess: "hro"
                resval: "1"
            },
            {
                bits: "5"
                name: slw
                desc: '''
                     
                '''
                swaccess: "rw"
                hwaccess: "hro"
                resval: "0"
            },
            {
                bits: "6"
                name: smt
                desc: '''
                     Schmit trigger enable
                '''
                swaccess: "rw"
                hwaccess: "hro"
                resval: "0"
            },
          ]
      }

       {
          name: B_21_MUX_SEL
          desc: '''
              Pad signal port multiplex selection for pad b_21. The programmed value defines which port
              is connected to the pad.
          '''
          swaccess: "rw"
          hwaccess: "hro"
          resval: 0
          fields: [
              {
                  bits: "1:0"
                  enum: [
                      { value: "0", name: "register", desc: "Connects the Pad to the internal configuration register."}
                      { value: "1", name: "port_cam1_cam_vsync", desc: "Connect port cam_vsync from port group cam1 to this pad." }
                      { value: "2", name: "port_gpio_b_gpio21", desc: "Connect port gpio21 from port group gpio_b to this pad." }
                  ]
              }
          ]
      }

      {
          name: B_22_CFG
          desc: '''
            Pad signal configuration.
          '''
          swaccess: "rw"
          fields: [
            {
                bits: "0"
                name: chip2pad
                desc: '''
                     The signal that connects to the pads TX driver
                '''
                swaccess: "rw"
                hwaccess: "hro"
                resval: "0"
            },
            {
                bits: "2:1"
                name: drv
                desc: '''
                     Driving strength
                '''
                swaccess: "rw"
                hwaccess: "hro"
                resval: "0"
            },
            {
                bits: "3"
                name: oen
                desc: '''
                     Output enable signal, active low
                '''
                swaccess: "rw"
                hwaccess: "hro"
                resval: "1"
            },
            {
                bits: "4"
                name: puen
                desc: '''
                     Pull-Up enable signal, active low
                '''
                swaccess: "rw"
                hwaccess: "hro"
                resval: "1"
            },
            {
                bits: "5"
                name: slw
                desc: '''
                     
                '''
                swaccess: "rw"
                hwaccess: "hro"
                resval: "0"
            },
            {
                bits: "6"
                name: smt
                desc: '''
                     Schmit trigger enable
                '''
                swaccess: "rw"
                hwaccess: "hro"
                resval: "0"
            },
          ]
      }

       {
          name: B_22_MUX_SEL
          desc: '''
              Pad signal port multiplex selection for pad b_22. The programmed value defines which port
              is connected to the pad.
          '''
          swaccess: "rw"
          hwaccess: "hro"
          resval: 0
          fields: [
              {
                  bits: "1:0"
                  enum: [
                      { value: "0", name: "register", desc: "Connects the Pad to the internal configuration register."}
                      { value: "1", name: "port_cam1_cam_data2_i", desc: "Connect port cam_data2_i from port group cam1 to this pad." }
                      { value: "2", name: "port_gpio_b_gpio22", desc: "Connect port gpio22 from port group gpio_b to this pad." }
                  ]
              }
          ]
      }

      {
          name: B_23_CFG
          desc: '''
            Pad signal configuration.
          '''
          swaccess: "rw"
          fields: [
            {
                bits: "0"
                name: chip2pad
                desc: '''
                     The signal that connects to the pads TX driver
                '''
                swaccess: "rw"
                hwaccess: "hro"
                resval: "0"
            },
            {
                bits: "2:1"
                name: drv
                desc: '''
                     Driving strength
                '''
                swaccess: "rw"
                hwaccess: "hro"
                resval: "0"
            },
            {
                bits: "3"
                name: oen
                desc: '''
                     Output enable signal, active low
                '''
                swaccess: "rw"
                hwaccess: "hro"
                resval: "1"
            },
            {
                bits: "4"
                name: puen
                desc: '''
                     Pull-Up enable signal, active low
                '''
                swaccess: "rw"
                hwaccess: "hro"
                resval: "1"
            },
            {
                bits: "5"
                name: slw
                desc: '''
                     
                '''
                swaccess: "rw"
                hwaccess: "hro"
                resval: "0"
            },
            {
                bits: "6"
                name: smt
                desc: '''
                     Schmit trigger enable
                '''
                swaccess: "rw"
                hwaccess: "hro"
                resval: "0"
            },
          ]
      }

       {
          name: B_23_MUX_SEL
          desc: '''
              Pad signal port multiplex selection for pad b_23. The programmed value defines which port
              is connected to the pad.
          '''
          swaccess: "rw"
          hwaccess: "hro"
          resval: 0
          fields: [
              {
                  bits: "1:0"
                  enum: [
                      { value: "0", name: "register", desc: "Connects the Pad to the internal configuration register."}
                      { value: "1", name: "port_cam1_cam_data3_i", desc: "Connect port cam_data3_i from port group cam1 to this pad." }
                      { value: "2", name: "port_gpio_b_gpio23", desc: "Connect port gpio23 from port group gpio_b to this pad." }
                  ]
              }
          ]
      }

      {
          name: B_24_CFG
          desc: '''
            Pad signal configuration.
          '''
          swaccess: "rw"
          fields: [
            {
                bits: "0"
                name: chip2pad
                desc: '''
                     The signal that connects to the pads TX driver
                '''
                swaccess: "rw"
                hwaccess: "hro"
                resval: "0"
            },
            {
                bits: "2:1"
                name: drv
                desc: '''
                     Driving strength
                '''
                swaccess: "rw"
                hwaccess: "hro"
                resval: "0"
            },
            {
                bits: "3"
                name: oen
                desc: '''
                     Output enable signal, active low
                '''
                swaccess: "rw"
                hwaccess: "hro"
                resval: "1"
            },
            {
                bits: "4"
                name: puen
                desc: '''
                     Pull-Up enable signal, active low
                '''
                swaccess: "rw"
                hwaccess: "hro"
                resval: "1"
            },
            {
                bits: "5"
                name: slw
                desc: '''
                     
                '''
                swaccess: "rw"
                hwaccess: "hro"
                resval: "0"
            },
            {
                bits: "6"
                name: smt
                desc: '''
                     Schmit trigger enable
                '''
                swaccess: "rw"
                hwaccess: "hro"
                resval: "0"
            },
          ]
      }

       {
          name: B_24_MUX_SEL
          desc: '''
              Pad signal port multiplex selection for pad b_24. The programmed value defines which port
              is connected to the pad.
          '''
          swaccess: "rw"
          hwaccess: "hro"
          resval: 0
          fields: [
              {
                  bits: "1:0"
                  enum: [
                      { value: "0", name: "register", desc: "Connects the Pad to the internal configuration register."}
                      { value: "1", name: "port_cam1_cam_data4_i", desc: "Connect port cam_data4_i from port group cam1 to this pad." }
                      { value: "2", name: "port_gpio_b_gpio24", desc: "Connect port gpio24 from port group gpio_b to this pad." }
                  ]
              }
          ]
      }

      {
          name: B_25_CFG
          desc: '''
            Pad signal configuration.
          '''
          swaccess: "rw"
          fields: [
            {
                bits: "0"
                name: chip2pad
                desc: '''
                     The signal that connects to the pads TX driver
                '''
                swaccess: "rw"
                hwaccess: "hro"
                resval: "0"
            },
            {
                bits: "2:1"
                name: drv
                desc: '''
                     Driving strength
                '''
                swaccess: "rw"
                hwaccess: "hro"
                resval: "0"
            },
            {
                bits: "3"
                name: oen
                desc: '''
                     Output enable signal, active low
                '''
                swaccess: "rw"
                hwaccess: "hro"
                resval: "1"
            },
            {
                bits: "4"
                name: puen
                desc: '''
                     Pull-Up enable signal, active low
                '''
                swaccess: "rw"
                hwaccess: "hro"
                resval: "1"
            },
            {
                bits: "5"
                name: slw
                desc: '''
                     
                '''
                swaccess: "rw"
                hwaccess: "hro"
                resval: "0"
            },
            {
                bits: "6"
                name: smt
                desc: '''
                     Schmit trigger enable
                '''
                swaccess: "rw"
                hwaccess: "hro"
                resval: "0"
            },
          ]
      }

       {
          name: B_25_MUX_SEL
          desc: '''
              Pad signal port multiplex selection for pad b_25. The programmed value defines which port
              is connected to the pad.
          '''
          swaccess: "rw"
          hwaccess: "hro"
          resval: 0
          fields: [
              {
                  bits: "1:0"
                  enum: [
                      { value: "0", name: "register", desc: "Connects the Pad to the internal configuration register."}
                      { value: "1", name: "port_gpio_b_gpio25", desc: "Connect port gpio25 from port group gpio_b to this pad." }
                      { value: "2", name: "port_sdio1_sdio_data1", desc: "Connect port sdio_data1 from port group sdio1 to this pad." }
                  ]
              }
          ]
      }

      {
          name: B_26_CFG
          desc: '''
            Pad signal configuration.
          '''
          swaccess: "rw"
          fields: [
            {
                bits: "0"
                name: chip2pad
                desc: '''
                     The signal that connects to the pads TX driver
                '''
                swaccess: "rw"
                hwaccess: "hro"
                resval: "0"
            },
            {
                bits: "2:1"
                name: drv
                desc: '''
                     Driving strength
                '''
                swaccess: "rw"
                hwaccess: "hro"
                resval: "0"
            },
            {
                bits: "3"
                name: oen
                desc: '''
                     Output enable signal, active low
                '''
                swaccess: "rw"
                hwaccess: "hro"
                resval: "1"
            },
            {
                bits: "4"
                name: puen
                desc: '''
                     Pull-Up enable signal, active low
                '''
                swaccess: "rw"
                hwaccess: "hro"
                resval: "1"
            },
            {
                bits: "5"
                name: slw
                desc: '''
                     
                '''
                swaccess: "rw"
                hwaccess: "hro"
                resval: "0"
            },
            {
                bits: "6"
                name: smt
                desc: '''
                     Schmit trigger enable
                '''
                swaccess: "rw"
                hwaccess: "hro"
                resval: "0"
            },
          ]
      }

       {
          name: B_26_MUX_SEL
          desc: '''
              Pad signal port multiplex selection for pad b_26. The programmed value defines which port
              is connected to the pad.
          '''
          swaccess: "rw"
          hwaccess: "hro"
          resval: 0
          fields: [
              {
                  bits: "0:0"
                  enum: [
                      { value: "0", name: "register", desc: "Connects the Pad to the internal configuration register."}
                      { value: "1", name: "port_gpio_b_gpio26", desc: "Connect port gpio26 from port group gpio_b to this pad." }
                  ]
              }
          ]
      }

      {
          name: B_27_CFG
          desc: '''
            Pad signal configuration.
          '''
          swaccess: "rw"
          fields: [
            {
                bits: "0"
                name: chip2pad
                desc: '''
                     The signal that connects to the pads TX driver
                '''
                swaccess: "rw"
                hwaccess: "hro"
                resval: "0"
            },
            {
                bits: "2:1"
                name: drv
                desc: '''
                     Driving strength
                '''
                swaccess: "rw"
                hwaccess: "hro"
                resval: "0"
            },
            {
                bits: "3"
                name: oen
                desc: '''
                     Output enable signal, active low
                '''
                swaccess: "rw"
                hwaccess: "hro"
                resval: "1"
            },
            {
                bits: "4"
                name: puen
                desc: '''
                     Pull-Up enable signal, active low
                '''
                swaccess: "rw"
                hwaccess: "hro"
                resval: "1"
            },
            {
                bits: "5"
                name: slw
                desc: '''
                     
                '''
                swaccess: "rw"
                hwaccess: "hro"
                resval: "0"
            },
            {
                bits: "6"
                name: smt
                desc: '''
                     Schmit trigger enable
                '''
                swaccess: "rw"
                hwaccess: "hro"
                resval: "0"
            },
          ]
      }

       {
          name: B_27_MUX_SEL
          desc: '''
              Pad signal port multiplex selection for pad b_27. The programmed value defines which port
              is connected to the pad.
          '''
          swaccess: "rw"
          hwaccess: "hro"
          resval: 0
          fields: [
              {
                  bits: "0:0"
                  enum: [
                      { value: "0", name: "register", desc: "Connects the Pad to the internal configuration register."}
                      { value: "1", name: "port_gpio_b_gpio27", desc: "Connect port gpio27 from port group gpio_b to this pad." }
                  ]
              }
          ]
      }

      {
          name: B_28_CFG
          desc: '''
            Pad signal configuration.
          '''
          swaccess: "rw"
          fields: [
            {
                bits: "0"
                name: chip2pad
                desc: '''
                     The signal that connects to the pads TX driver
                '''
                swaccess: "rw"
                hwaccess: "hro"
                resval: "0"
            },
            {
                bits: "2:1"
                name: drv
                desc: '''
                     Driving strength
                '''
                swaccess: "rw"
                hwaccess: "hro"
                resval: "0"
            },
            {
                bits: "3"
                name: oen
                desc: '''
                     Output enable signal, active low
                '''
                swaccess: "rw"
                hwaccess: "hro"
                resval: "1"
            },
            {
                bits: "4"
                name: puen
                desc: '''
                     Pull-Up enable signal, active low
                '''
                swaccess: "rw"
                hwaccess: "hro"
                resval: "1"
            },
            {
                bits: "5"
                name: slw
                desc: '''
                     
                '''
                swaccess: "rw"
                hwaccess: "hro"
                resval: "0"
            },
            {
                bits: "6"
                name: smt
                desc: '''
                     Schmit trigger enable
                '''
                swaccess: "rw"
                hwaccess: "hro"
                resval: "0"
            },
          ]
      }

       {
          name: B_28_MUX_SEL
          desc: '''
              Pad signal port multiplex selection for pad b_28. The programmed value defines which port
              is connected to the pad.
          '''
          swaccess: "rw"
          hwaccess: "hro"
          resval: 0
          fields: [
              {
                  bits: "0:0"
                  enum: [
                      { value: "0", name: "register", desc: "Connects the Pad to the internal configuration register."}
                      { value: "1", name: "port_gpio_b_gpio28", desc: "Connect port gpio28 from port group gpio_b to this pad." }
                  ]
              }
          ]
      }

      {
          name: B_29_CFG
          desc: '''
            Pad signal configuration.
          '''
          swaccess: "rw"
          fields: [
            {
                bits: "0"
                name: chip2pad
                desc: '''
                     The signal that connects to the pads TX driver
                '''
                swaccess: "rw"
                hwaccess: "hro"
                resval: "0"
            },
            {
                bits: "2:1"
                name: drv
                desc: '''
                     Driving strength
                '''
                swaccess: "rw"
                hwaccess: "hro"
                resval: "0"
            },
            {
                bits: "3"
                name: oen
                desc: '''
                     Output enable signal, active low
                '''
                swaccess: "rw"
                hwaccess: "hro"
                resval: "1"
            },
            {
                bits: "4"
                name: puen
                desc: '''
                     Pull-Up enable signal, active low
                '''
                swaccess: "rw"
                hwaccess: "hro"
                resval: "1"
            },
            {
                bits: "5"
                name: slw
                desc: '''
                     
                '''
                swaccess: "rw"
                hwaccess: "hro"
                resval: "0"
            },
            {
                bits: "6"
                name: smt
                desc: '''
                     Schmit trigger enable
                '''
                swaccess: "rw"
                hwaccess: "hro"
                resval: "0"
            },
          ]
      }

       {
          name: B_29_MUX_SEL
          desc: '''
              Pad signal port multiplex selection for pad b_29. The programmed value defines which port
              is connected to the pad.
          '''
          swaccess: "rw"
          hwaccess: "hro"
          resval: 0
          fields: [
              {
                  bits: "0:0"
                  enum: [
                      { value: "0", name: "register", desc: "Connects the Pad to the internal configuration register."}
                      { value: "1", name: "port_gpio_b_gpio29", desc: "Connect port gpio29 from port group gpio_b to this pad." }
                  ]
              }
          ]
      }

      {
          name: B_30_CFG
          desc: '''
            Pad signal configuration.
          '''
          swaccess: "rw"
          fields: [
            {
                bits: "0"
                name: chip2pad
                desc: '''
                     The signal that connects to the pads TX driver
                '''
                swaccess: "rw"
                hwaccess: "hro"
                resval: "0"
            },
            {
                bits: "2:1"
                name: drv
                desc: '''
                     Driving strength
                '''
                swaccess: "rw"
                hwaccess: "hro"
                resval: "0"
            },
            {
                bits: "3"
                name: oen
                desc: '''
                     Output enable signal, active low
                '''
                swaccess: "rw"
                hwaccess: "hro"
                resval: "1"
            },
            {
                bits: "4"
                name: puen
                desc: '''
                     Pull-Up enable signal, active low
                '''
                swaccess: "rw"
                hwaccess: "hro"
                resval: "1"
            },
            {
                bits: "5"
                name: slw
                desc: '''
                     
                '''
                swaccess: "rw"
                hwaccess: "hro"
                resval: "0"
            },
            {
                bits: "6"
                name: smt
                desc: '''
                     Schmit trigger enable
                '''
                swaccess: "rw"
                hwaccess: "hro"
                resval: "0"
            },
          ]
      }

       {
          name: B_30_MUX_SEL
          desc: '''
              Pad signal port multiplex selection for pad b_30. The programmed value defines which port
              is connected to the pad.
          '''
          swaccess: "rw"
          hwaccess: "hro"
          resval: 0
          fields: [
              {
                  bits: "0:0"
                  enum: [
                      { value: "0", name: "register", desc: "Connects the Pad to the internal configuration register."}
                      { value: "1", name: "port_gpio_b_gpio30", desc: "Connect port gpio30 from port group gpio_b to this pad." }
                  ]
              }
          ]
      }

      {
          name: B_31_CFG
          desc: '''
            Pad signal configuration.
          '''
          swaccess: "rw"
          fields: [
            {
                bits: "0"
                name: chip2pad
                desc: '''
                     The signal that connects to the pads TX driver
                '''
                swaccess: "rw"
                hwaccess: "hro"
                resval: "0"
            },
            {
                bits: "2:1"
                name: drv
                desc: '''
                     Driving strength
                '''
                swaccess: "rw"
                hwaccess: "hro"
                resval: "0"
            },
            {
                bits: "3"
                name: oen
                desc: '''
                     Output enable signal, active low
                '''
                swaccess: "rw"
                hwaccess: "hro"
                resval: "1"
            },
            {
                bits: "4"
                name: puen
                desc: '''
                     Pull-Up enable signal, active low
                '''
                swaccess: "rw"
                hwaccess: "hro"
                resval: "1"
            },
            {
                bits: "5"
                name: slw
                desc: '''
                     
                '''
                swaccess: "rw"
                hwaccess: "hro"
                resval: "0"
            },
            {
                bits: "6"
                name: smt
                desc: '''
                     Schmit trigger enable
                '''
                swaccess: "rw"
                hwaccess: "hro"
                resval: "0"
            },
          ]
      }

       {
          name: B_31_MUX_SEL
          desc: '''
              Pad signal port multiplex selection for pad b_31. The programmed value defines which port
              is connected to the pad.
          '''
          swaccess: "rw"
          hwaccess: "hro"
          resval: 0
          fields: [
              {
                  bits: "0:0"
                  enum: [
                      { value: "0", name: "register", desc: "Connects the Pad to the internal configuration register."}
                      { value: "1", name: "port_gpio_b_gpio31", desc: "Connect port gpio31 from port group gpio_b to this pad." }
                  ]
              }
          ]
      }

      {
          name: B_32_CFG
          desc: '''
            Pad signal configuration.
          '''
          swaccess: "rw"
          fields: [
            {
                bits: "0"
                name: chip2pad
                desc: '''
                     The signal that connects to the pads TX driver
                '''
                swaccess: "rw"
                hwaccess: "hro"
                resval: "0"
            },
            {
                bits: "2:1"
                name: drv
                desc: '''
                     Driving strength
                '''
                swaccess: "rw"
                hwaccess: "hro"
                resval: "0"
            },
            {
                bits: "3"
                name: oen
                desc: '''
                     Output enable signal, active low
                '''
                swaccess: "rw"
                hwaccess: "hro"
                resval: "1"
            },
            {
                bits: "4"
                name: puen
                desc: '''
                     Pull-Up enable signal, active low
                '''
                swaccess: "rw"
                hwaccess: "hro"
                resval: "1"
            },
            {
                bits: "5"
                name: slw
                desc: '''
                     
                '''
                swaccess: "rw"
                hwaccess: "hro"
                resval: "0"
            },
            {
                bits: "6"
                name: smt
                desc: '''
                     Schmit trigger enable
                '''
                swaccess: "rw"
                hwaccess: "hro"
                resval: "0"
            },
          ]
      }

       {
          name: B_32_MUX_SEL
          desc: '''
              Pad signal port multiplex selection for pad b_32. The programmed value defines which port
              is connected to the pad.
          '''
          swaccess: "rw"
          hwaccess: "hro"
          resval: 0
          fields: [
              {
                  bits: "0:0"
                  enum: [
                      { value: "0", name: "register", desc: "Connects the Pad to the internal configuration register."}
                      { value: "1", name: "port_gpio_b_gpio32", desc: "Connect port gpio32 from port group gpio_b to this pad." }
                  ]
              }
          ]
      }

      {
          name: B_33_CFG
          desc: '''
            Pad signal configuration.
          '''
          swaccess: "rw"
          fields: [
            {
                bits: "0"
                name: chip2pad
                desc: '''
                     The signal that connects to the pads TX driver
                '''
                swaccess: "rw"
                hwaccess: "hro"
                resval: "0"
            },
            {
                bits: "2:1"
                name: drv
                desc: '''
                     Driving strength
                '''
                swaccess: "rw"
                hwaccess: "hro"
                resval: "0"
            },
            {
                bits: "3"
                name: oen
                desc: '''
                     Output enable signal, active low
                '''
                swaccess: "rw"
                hwaccess: "hro"
                resval: "1"
            },
            {
                bits: "4"
                name: puen
                desc: '''
                     Pull-Up enable signal, active low
                '''
                swaccess: "rw"
                hwaccess: "hro"
                resval: "1"
            },
            {
                bits: "5"
                name: slw
                desc: '''
                     
                '''
                swaccess: "rw"
                hwaccess: "hro"
                resval: "0"
            },
            {
                bits: "6"
                name: smt
                desc: '''
                     Schmit trigger enable
                '''
                swaccess: "rw"
                hwaccess: "hro"
                resval: "0"
            },
          ]
      }

       {
          name: B_33_MUX_SEL
          desc: '''
              Pad signal port multiplex selection for pad b_33. The programmed value defines which port
              is connected to the pad.
          '''
          swaccess: "rw"
          hwaccess: "hro"
          resval: 0
          fields: [
              {
                  bits: "0:0"
                  enum: [
                      { value: "0", name: "register", desc: "Connects the Pad to the internal configuration register."}
                      { value: "1", name: "port_gpio_b_gpio33", desc: "Connect port gpio33 from port group gpio_b to this pad." }
                  ]
              }
          ]
      }

      {
          name: B_34_CFG
          desc: '''
            Pad signal configuration.
          '''
          swaccess: "rw"
          fields: [
            {
                bits: "0"
                name: chip2pad
                desc: '''
                     The signal that connects to the pads TX driver
                '''
                swaccess: "rw"
                hwaccess: "hro"
                resval: "0"
            },
            {
                bits: "2:1"
                name: drv
                desc: '''
                     Driving strength
                '''
                swaccess: "rw"
                hwaccess: "hro"
                resval: "0"
            },
            {
                bits: "3"
                name: oen
                desc: '''
                     Output enable signal, active low
                '''
                swaccess: "rw"
                hwaccess: "hro"
                resval: "1"
            },
            {
                bits: "4"
                name: puen
                desc: '''
                     Pull-Up enable signal, active low
                '''
                swaccess: "rw"
                hwaccess: "hro"
                resval: "1"
            },
            {
                bits: "5"
                name: slw
                desc: '''
                     
                '''
                swaccess: "rw"
                hwaccess: "hro"
                resval: "0"
            },
            {
                bits: "6"
                name: smt
                desc: '''
                     Schmit trigger enable
                '''
                swaccess: "rw"
                hwaccess: "hro"
                resval: "0"
            },
          ]
      }

       {
          name: B_34_MUX_SEL
          desc: '''
              Pad signal port multiplex selection for pad b_34. The programmed value defines which port
              is connected to the pad.
          '''
          swaccess: "rw"
          hwaccess: "hro"
          resval: 0
          fields: [
              {
                  bits: "0:0"
                  enum: [
                      { value: "0", name: "register", desc: "Connects the Pad to the internal configuration register."}
                      { value: "1", name: "port_gpio_b_gpio34", desc: "Connect port gpio34 from port group gpio_b to this pad." }
                  ]
              }
          ]
      }

      {
          name: B_35_CFG
          desc: '''
            Pad signal configuration.
          '''
          swaccess: "rw"
          fields: [
            {
                bits: "0"
                name: chip2pad
                desc: '''
                     The signal that connects to the pads TX driver
                '''
                swaccess: "rw"
                hwaccess: "hro"
                resval: "0"
            },
            {
                bits: "2:1"
                name: drv
                desc: '''
                     Driving strength
                '''
                swaccess: "rw"
                hwaccess: "hro"
                resval: "0"
            },
            {
                bits: "3"
                name: oen
                desc: '''
                     Output enable signal, active low
                '''
                swaccess: "rw"
                hwaccess: "hro"
                resval: "1"
            },
            {
                bits: "4"
                name: puen
                desc: '''
                     Pull-Up enable signal, active low
                '''
                swaccess: "rw"
                hwaccess: "hro"
                resval: "1"
            },
            {
                bits: "5"
                name: slw
                desc: '''
                     
                '''
                swaccess: "rw"
                hwaccess: "hro"
                resval: "0"
            },
            {
                bits: "6"
                name: smt
                desc: '''
                     Schmit trigger enable
                '''
                swaccess: "rw"
                hwaccess: "hro"
                resval: "0"
            },
          ]
      }

       {
          name: B_35_MUX_SEL
          desc: '''
              Pad signal port multiplex selection for pad b_35. The programmed value defines which port
              is connected to the pad.
          '''
          swaccess: "rw"
          hwaccess: "hro"
          resval: 0
          fields: [
              {
                  bits: "0:0"
                  enum: [
                      { value: "0", name: "register", desc: "Connects the Pad to the internal configuration register."}
                      { value: "1", name: "port_gpio_b_gpio35", desc: "Connect port gpio35 from port group gpio_b to this pad." }
                  ]
              }
          ]
      }

      {
          name: B_36_CFG
          desc: '''
            Pad signal configuration.
          '''
          swaccess: "rw"
          fields: [
            {
                bits: "0"
                name: chip2pad
                desc: '''
                     The signal that connects to the pads TX driver
                '''
                swaccess: "rw"
                hwaccess: "hro"
                resval: "0"
            },
            {
                bits: "2:1"
                name: drv
                desc: '''
                     Driving strength
                '''
                swaccess: "rw"
                hwaccess: "hro"
                resval: "0"
            },
            {
                bits: "3"
                name: oen
                desc: '''
                     Output enable signal, active low
                '''
                swaccess: "rw"
                hwaccess: "hro"
                resval: "1"
            },
            {
                bits: "4"
                name: puen
                desc: '''
                     Pull-Up enable signal, active low
                '''
                swaccess: "rw"
                hwaccess: "hro"
                resval: "1"
            },
            {
                bits: "5"
                name: slw
                desc: '''
                     
                '''
                swaccess: "rw"
                hwaccess: "hro"
                resval: "0"
            },
            {
                bits: "6"
                name: smt
                desc: '''
                     Schmit trigger enable
                '''
                swaccess: "rw"
                hwaccess: "hro"
                resval: "0"
            },
          ]
      }

       {
          name: B_36_MUX_SEL
          desc: '''
              Pad signal port multiplex selection for pad b_36. The programmed value defines which port
              is connected to the pad.
          '''
          swaccess: "rw"
          hwaccess: "hro"
          resval: 0
          fields: [
              {
                  bits: "0:0"
                  enum: [
                      { value: "0", name: "register", desc: "Connects the Pad to the internal configuration register."}
                      { value: "1", name: "port_gpio_b_gpio36", desc: "Connect port gpio36 from port group gpio_b to this pad." }
                  ]
              }
          ]
      }

      {
          name: B_37_CFG
          desc: '''
            Pad signal configuration.
          '''
          swaccess: "rw"
          fields: [
            {
                bits: "0"
                name: chip2pad
                desc: '''
                     The signal that connects to the pads TX driver
                '''
                swaccess: "rw"
                hwaccess: "hro"
                resval: "0"
            },
            {
                bits: "2:1"
                name: drv
                desc: '''
                     Driving strength
                '''
                swaccess: "rw"
                hwaccess: "hro"
                resval: "0"
            },
            {
                bits: "3"
                name: oen
                desc: '''
                     Output enable signal, active low
                '''
                swaccess: "rw"
                hwaccess: "hro"
                resval: "1"
            },
            {
                bits: "4"
                name: puen
                desc: '''
                     Pull-Up enable signal, active low
                '''
                swaccess: "rw"
                hwaccess: "hro"
                resval: "1"
            },
            {
                bits: "5"
                name: slw
                desc: '''
                     
                '''
                swaccess: "rw"
                hwaccess: "hro"
                resval: "0"
            },
            {
                bits: "6"
                name: smt
                desc: '''
                     Schmit trigger enable
                '''
                swaccess: "rw"
                hwaccess: "hro"
                resval: "0"
            },
          ]
      }

       {
          name: B_37_MUX_SEL
          desc: '''
              Pad signal port multiplex selection for pad b_37. The programmed value defines which port
              is connected to the pad.
          '''
          swaccess: "rw"
          hwaccess: "hro"
          resval: 0
          fields: [
              {
                  bits: "0:0"
                  enum: [
                      { value: "0", name: "register", desc: "Connects the Pad to the internal configuration register."}
                      { value: "1", name: "port_gpio_b_gpio37", desc: "Connect port gpio37 from port group gpio_b to this pad." }
                  ]
              }
          ]
      }

      {
          name: B_38_CFG
          desc: '''
            Pad signal configuration.
          '''
          swaccess: "rw"
          fields: [
            {
                bits: "0"
                name: chip2pad
                desc: '''
                     The signal that connects to the pads TX driver
                '''
                swaccess: "rw"
                hwaccess: "hro"
                resval: "0"
            },
            {
                bits: "2:1"
                name: drv
                desc: '''
                     Driving strength
                '''
                swaccess: "rw"
                hwaccess: "hro"
                resval: "0"
            },
            {
                bits: "3"
                name: oen
                desc: '''
                     Output enable signal, active low
                '''
                swaccess: "rw"
                hwaccess: "hro"
                resval: "1"
            },
            {
                bits: "4"
                name: puen
                desc: '''
                     Pull-Up enable signal, active low
                '''
                swaccess: "rw"
                hwaccess: "hro"
                resval: "1"
            },
            {
                bits: "5"
                name: slw
                desc: '''
                     
                '''
                swaccess: "rw"
                hwaccess: "hro"
                resval: "0"
            },
            {
                bits: "6"
                name: smt
                desc: '''
                     Schmit trigger enable
                '''
                swaccess: "rw"
                hwaccess: "hro"
                resval: "0"
            },
          ]
      }

       {
          name: B_38_MUX_SEL
          desc: '''
              Pad signal port multiplex selection for pad b_38. The programmed value defines which port
              is connected to the pad.
          '''
          swaccess: "rw"
          hwaccess: "hro"
          resval: 0
          fields: [
              {
                  bits: "0:0"
                  enum: [
                      { value: "0", name: "register", desc: "Connects the Pad to the internal configuration register."}
                      { value: "1", name: "port_gpio_b_gpio38", desc: "Connect port gpio38 from port group gpio_b to this pad." }
                  ]
              }
          ]
      }

      {
          name: B_39_CFG
          desc: '''
            Pad signal configuration.
          '''
          swaccess: "rw"
          fields: [
            {
                bits: "0"
                name: chip2pad
                desc: '''
                     The signal that connects to the pads TX driver
                '''
                swaccess: "rw"
                hwaccess: "hro"
                resval: "0"
            },
            {
                bits: "2:1"
                name: drv
                desc: '''
                     Driving strength
                '''
                swaccess: "rw"
                hwaccess: "hro"
                resval: "0"
            },
            {
                bits: "3"
                name: oen
                desc: '''
                     Output enable signal, active low
                '''
                swaccess: "rw"
                hwaccess: "hro"
                resval: "1"
            },
            {
                bits: "4"
                name: puen
                desc: '''
                     Pull-Up enable signal, active low
                '''
                swaccess: "rw"
                hwaccess: "hro"
                resval: "1"
            },
            {
                bits: "5"
                name: slw
                desc: '''
                     
                '''
                swaccess: "rw"
                hwaccess: "hro"
                resval: "0"
            },
            {
                bits: "6"
                name: smt
                desc: '''
                     Schmit trigger enable
                '''
                swaccess: "rw"
                hwaccess: "hro"
                resval: "0"
            },
          ]
      }

       {
          name: B_39_MUX_SEL
          desc: '''
              Pad signal port multiplex selection for pad b_39. The programmed value defines which port
              is connected to the pad.
          '''
          swaccess: "rw"
          hwaccess: "hro"
          resval: 0
          fields: [
              {
                  bits: "0:0"
                  enum: [
                      { value: "0", name: "register", desc: "Connects the Pad to the internal configuration register."}
                      { value: "1", name: "port_gpio_b_gpio39", desc: "Connect port gpio39 from port group gpio_b to this pad." }
                  ]
              }
          ]
      }

      {
          name: B_40_CFG
          desc: '''
            Pad signal configuration.
          '''
          swaccess: "rw"
          fields: [
            {
                bits: "0"
                name: chip2pad
                desc: '''
                     The signal that connects to the pads TX driver
                '''
                swaccess: "rw"
                hwaccess: "hro"
                resval: "0"
            },
            {
                bits: "2:1"
                name: drv
                desc: '''
                     Driving strength
                '''
                swaccess: "rw"
                hwaccess: "hro"
                resval: "0"
            },
            {
                bits: "3"
                name: oen
                desc: '''
                     Output enable signal, active low
                '''
                swaccess: "rw"
                hwaccess: "hro"
                resval: "1"
            },
            {
                bits: "4"
                name: puen
                desc: '''
                     Pull-Up enable signal, active low
                '''
                swaccess: "rw"
                hwaccess: "hro"
                resval: "1"
            },
            {
                bits: "5"
                name: slw
                desc: '''
                     
                '''
                swaccess: "rw"
                hwaccess: "hro"
                resval: "0"
            },
            {
                bits: "6"
                name: smt
                desc: '''
                     Schmit trigger enable
                '''
                swaccess: "rw"
                hwaccess: "hro"
                resval: "0"
            },
          ]
      }

       {
          name: B_40_MUX_SEL
          desc: '''
              Pad signal port multiplex selection for pad b_40. The programmed value defines which port
              is connected to the pad.
          '''
          swaccess: "rw"
          hwaccess: "hro"
          resval: 0
          fields: [
              {
                  bits: "0:0"
                  enum: [
                      { value: "0", name: "register", desc: "Connects the Pad to the internal configuration register."}
                      { value: "1", name: "port_gpio_b_gpio40", desc: "Connect port gpio40 from port group gpio_b to this pad." }
                  ]
              }
          ]
      }

      {
          name: B_41_CFG
          desc: '''
            Pad signal configuration.
          '''
          swaccess: "rw"
          fields: [
            {
                bits: "0"
                name: chip2pad
                desc: '''
                     The signal that connects to the pads TX driver
                '''
                swaccess: "rw"
                hwaccess: "hro"
                resval: "0"
            },
            {
                bits: "2:1"
                name: drv
                desc: '''
                     Driving strength
                '''
                swaccess: "rw"
                hwaccess: "hro"
                resval: "0"
            },
            {
                bits: "3"
                name: oen
                desc: '''
                     Output enable signal, active low
                '''
                swaccess: "rw"
                hwaccess: "hro"
                resval: "1"
            },
            {
                bits: "4"
                name: puen
                desc: '''
                     Pull-Up enable signal, active low
                '''
                swaccess: "rw"
                hwaccess: "hro"
                resval: "1"
            },
            {
                bits: "5"
                name: slw
                desc: '''
                     
                '''
                swaccess: "rw"
                hwaccess: "hro"
                resval: "0"
            },
            {
                bits: "6"
                name: smt
                desc: '''
                     Schmit trigger enable
                '''
                swaccess: "rw"
                hwaccess: "hro"
                resval: "0"
            },
          ]
      }

       {
          name: B_41_MUX_SEL
          desc: '''
              Pad signal port multiplex selection for pad b_41. The programmed value defines which port
              is connected to the pad.
          '''
          swaccess: "rw"
          hwaccess: "hro"
          resval: 0
          fields: [
              {
                  bits: "0:0"
                  enum: [
                      { value: "0", name: "register", desc: "Connects the Pad to the internal configuration register."}
                      { value: "1", name: "port_gpio_b_gpio41", desc: "Connect port gpio41 from port group gpio_b to this pad." }
                  ]
              }
          ]
      }

      {
          name: B_42_CFG
          desc: '''
            Pad signal configuration.
          '''
          swaccess: "rw"
          fields: [
            {
                bits: "0"
                name: chip2pad
                desc: '''
                     The signal that connects to the pads TX driver
                '''
                swaccess: "rw"
                hwaccess: "hro"
                resval: "0"
            },
            {
                bits: "2:1"
                name: drv
                desc: '''
                     Driving strength
                '''
                swaccess: "rw"
                hwaccess: "hro"
                resval: "0"
            },
            {
                bits: "3"
                name: oen
                desc: '''
                     Output enable signal, active low
                '''
                swaccess: "rw"
                hwaccess: "hro"
                resval: "1"
            },
            {
                bits: "4"
                name: puen
                desc: '''
                     Pull-Up enable signal, active low
                '''
                swaccess: "rw"
                hwaccess: "hro"
                resval: "1"
            },
            {
                bits: "5"
                name: slw
                desc: '''
                     
                '''
                swaccess: "rw"
                hwaccess: "hro"
                resval: "0"
            },
            {
                bits: "6"
                name: smt
                desc: '''
                     Schmit trigger enable
                '''
                swaccess: "rw"
                hwaccess: "hro"
                resval: "0"
            },
          ]
      }

       {
          name: B_42_MUX_SEL
          desc: '''
              Pad signal port multiplex selection for pad b_42. The programmed value defines which port
              is connected to the pad.
          '''
          swaccess: "rw"
          hwaccess: "hro"
          resval: 0
          fields: [
              {
                  bits: "0:0"
                  enum: [
                      { value: "0", name: "register", desc: "Connects the Pad to the internal configuration register."}
                      { value: "1", name: "port_gpio_b_gpio42", desc: "Connect port gpio42 from port group gpio_b to this pad." }
                  ]
              }
          ]
      }

      {
          name: B_43_CFG
          desc: '''
            Pad signal configuration.
          '''
          swaccess: "rw"
          fields: [
            {
                bits: "0"
                name: chip2pad
                desc: '''
                     The signal that connects to the pads TX driver
                '''
                swaccess: "rw"
                hwaccess: "hro"
                resval: "0"
            },
            {
                bits: "2:1"
                name: drv
                desc: '''
                     Driving strength
                '''
                swaccess: "rw"
                hwaccess: "hro"
                resval: "0"
            },
            {
                bits: "3"
                name: oen
                desc: '''
                     Output enable signal, active low
                '''
                swaccess: "rw"
                hwaccess: "hro"
                resval: "1"
            },
            {
                bits: "4"
                name: puen
                desc: '''
                     Pull-Up enable signal, active low
                '''
                swaccess: "rw"
                hwaccess: "hro"
                resval: "1"
            },
            {
                bits: "5"
                name: slw
                desc: '''
                     
                '''
                swaccess: "rw"
                hwaccess: "hro"
                resval: "0"
            },
            {
                bits: "6"
                name: smt
                desc: '''
                     Schmit trigger enable
                '''
                swaccess: "rw"
                hwaccess: "hro"
                resval: "0"
            },
          ]
      }

       {
          name: B_43_MUX_SEL
          desc: '''
              Pad signal port multiplex selection for pad b_43. The programmed value defines which port
              is connected to the pad.
          '''
          swaccess: "rw"
          hwaccess: "hro"
          resval: 0
          fields: [
              {
                  bits: "0:0"
                  enum: [
                      { value: "0", name: "register", desc: "Connects the Pad to the internal configuration register."}
                      { value: "1", name: "port_gpio_b_gpio43", desc: "Connect port gpio43 from port group gpio_b to this pad." }
                  ]
              }
          ]
      }

      {
          name: B_44_CFG
          desc: '''
            Pad signal configuration.
          '''
          swaccess: "rw"
          fields: [
            {
                bits: "0"
                name: chip2pad
                desc: '''
                     The signal that connects to the pads TX driver
                '''
                swaccess: "rw"
                hwaccess: "hro"
                resval: "0"
            },
            {
                bits: "2:1"
                name: drv
                desc: '''
                     Driving strength
                '''
                swaccess: "rw"
                hwaccess: "hro"
                resval: "0"
            },
            {
                bits: "3"
                name: oen
                desc: '''
                     Output enable signal, active low
                '''
                swaccess: "rw"
                hwaccess: "hro"
                resval: "1"
            },
            {
                bits: "4"
                name: puen
                desc: '''
                     Pull-Up enable signal, active low
                '''
                swaccess: "rw"
                hwaccess: "hro"
                resval: "1"
            },
            {
                bits: "5"
                name: slw
                desc: '''
                     
                '''
                swaccess: "rw"
                hwaccess: "hro"
                resval: "0"
            },
            {
                bits: "6"
                name: smt
                desc: '''
                     Schmit trigger enable
                '''
                swaccess: "rw"
                hwaccess: "hro"
                resval: "0"
            },
          ]
      }

       {
          name: B_44_MUX_SEL
          desc: '''
              Pad signal port multiplex selection for pad b_44. The programmed value defines which port
              is connected to the pad.
          '''
          swaccess: "rw"
          hwaccess: "hro"
          resval: 0
          fields: [
              {
                  bits: "0:0"
                  enum: [
                      { value: "0", name: "register", desc: "Connects the Pad to the internal configuration register."}
                      { value: "1", name: "port_gpio_b_gpio44", desc: "Connect port gpio44 from port group gpio_b to this pad." }
                  ]
              }
          ]
      }

      {
          name: B_45_CFG
          desc: '''
            Pad signal configuration.
          '''
          swaccess: "rw"
          fields: [
            {
                bits: "0"
                name: chip2pad
                desc: '''
                     The signal that connects to the pads TX driver
                '''
                swaccess: "rw"
                hwaccess: "hro"
                resval: "0"
            },
            {
                bits: "2:1"
                name: drv
                desc: '''
                     Driving strength
                '''
                swaccess: "rw"
                hwaccess: "hro"
                resval: "0"
            },
            {
                bits: "3"
                name: oen
                desc: '''
                     Output enable signal, active low
                '''
                swaccess: "rw"
                hwaccess: "hro"
                resval: "1"
            },
            {
                bits: "4"
                name: puen
                desc: '''
                     Pull-Up enable signal, active low
                '''
                swaccess: "rw"
                hwaccess: "hro"
                resval: "1"
            },
            {
                bits: "5"
                name: slw
                desc: '''
                     
                '''
                swaccess: "rw"
                hwaccess: "hro"
                resval: "0"
            },
            {
                bits: "6"
                name: smt
                desc: '''
                     Schmit trigger enable
                '''
                swaccess: "rw"
                hwaccess: "hro"
                resval: "0"
            },
          ]
      }

       {
          name: B_45_MUX_SEL
          desc: '''
              Pad signal port multiplex selection for pad b_45. The programmed value defines which port
              is connected to the pad.
          '''
          swaccess: "rw"
          hwaccess: "hro"
          resval: 0
          fields: [
              {
                  bits: "0:0"
                  enum: [
                      { value: "0", name: "register", desc: "Connects the Pad to the internal configuration register."}
                      { value: "1", name: "port_gpio_b_gpio45", desc: "Connect port gpio45 from port group gpio_b to this pad." }
                  ]
              }
          ]
      }

      {
          name: B_46_CFG
          desc: '''
            Pad signal configuration.
          '''
          swaccess: "rw"
          fields: [
            {
                bits: "0"
                name: chip2pad
                desc: '''
                     The signal that connects to the pads TX driver
                '''
                swaccess: "rw"
                hwaccess: "hro"
                resval: "0"
            },
            {
                bits: "2:1"
                name: drv
                desc: '''
                     Driving strength
                '''
                swaccess: "rw"
                hwaccess: "hro"
                resval: "0"
            },
            {
                bits: "3"
                name: oen
                desc: '''
                     Output enable signal, active low
                '''
                swaccess: "rw"
                hwaccess: "hro"
                resval: "1"
            },
            {
                bits: "4"
                name: puen
                desc: '''
                     Pull-Up enable signal, active low
                '''
                swaccess: "rw"
                hwaccess: "hro"
                resval: "1"
            },
            {
                bits: "5"
                name: slw
                desc: '''
                     
                '''
                swaccess: "rw"
                hwaccess: "hro"
                resval: "0"
            },
            {
                bits: "6"
                name: smt
                desc: '''
                     Schmit trigger enable
                '''
                swaccess: "rw"
                hwaccess: "hro"
                resval: "0"
            },
          ]
      }

       {
          name: B_46_MUX_SEL
          desc: '''
              Pad signal port multiplex selection for pad b_46. The programmed value defines which port
              is connected to the pad.
          '''
          swaccess: "rw"
          hwaccess: "hro"
          resval: 0
          fields: [
              {
                  bits: "0:0"
                  enum: [
                      { value: "0", name: "register", desc: "Connects the Pad to the internal configuration register."}
                      { value: "1", name: "port_gpio_b_gpio46", desc: "Connect port gpio46 from port group gpio_b to this pad." }
                  ]
              }
          ]
      }

      {
          name: B_47_CFG
          desc: '''
            Pad signal configuration.
          '''
          swaccess: "rw"
          fields: [
            {
                bits: "0"
                name: chip2pad
                desc: '''
                     The signal that connects to the pads TX driver
                '''
                swaccess: "rw"
                hwaccess: "hro"
                resval: "0"
            },
            {
                bits: "2:1"
                name: drv
                desc: '''
                     Driving strength
                '''
                swaccess: "rw"
                hwaccess: "hro"
                resval: "0"
            },
            {
                bits: "3"
                name: oen
                desc: '''
                     Output enable signal, active low
                '''
                swaccess: "rw"
                hwaccess: "hro"
                resval: "1"
            },
            {
                bits: "4"
                name: puen
                desc: '''
                     Pull-Up enable signal, active low
                '''
                swaccess: "rw"
                hwaccess: "hro"
                resval: "1"
            },
            {
                bits: "5"
                name: slw
                desc: '''
                     
                '''
                swaccess: "rw"
                hwaccess: "hro"
                resval: "0"
            },
            {
                bits: "6"
                name: smt
                desc: '''
                     Schmit trigger enable
                '''
                swaccess: "rw"
                hwaccess: "hro"
                resval: "0"
            },
          ]
      }

       {
          name: B_47_MUX_SEL
          desc: '''
              Pad signal port multiplex selection for pad b_47. The programmed value defines which port
              is connected to the pad.
          '''
          swaccess: "rw"
          hwaccess: "hro"
          resval: 0
          fields: [
              {
                  bits: "1:0"
                  enum: [
                      { value: "0", name: "register", desc: "Connects the Pad to the internal configuration register."}
                      { value: "1", name: "port_eth_eth_rst", desc: "Connect port eth_rst from port group eth to this pad." }
                      { value: "2", name: "port_gpio_b_gpio47", desc: "Connect port gpio47 from port group gpio_b to this pad." }
                  ]
              }
          ]
      }

      {
          name: B_48_CFG
          desc: '''
            Pad signal configuration.
          '''
          swaccess: "rw"
          fields: [
            {
                bits: "0"
                name: chip2pad
                desc: '''
                     The signal that connects to the pads TX driver
                '''
                swaccess: "rw"
                hwaccess: "hro"
                resval: "0"
            },
            {
                bits: "2:1"
                name: drv
                desc: '''
                     Driving strength
                '''
                swaccess: "rw"
                hwaccess: "hro"
                resval: "0"
            },
            {
                bits: "3"
                name: oen
                desc: '''
                     Output enable signal, active low
                '''
                swaccess: "rw"
                hwaccess: "hro"
                resval: "1"
            },
            {
                bits: "4"
                name: puen
                desc: '''
                     Pull-Up enable signal, active low
                '''
                swaccess: "rw"
                hwaccess: "hro"
                resval: "1"
            },
            {
                bits: "5"
                name: slw
                desc: '''
                     
                '''
                swaccess: "rw"
                hwaccess: "hro"
                resval: "0"
            },
            {
                bits: "6"
                name: smt
                desc: '''
                     Schmit trigger enable
                '''
                swaccess: "rw"
                hwaccess: "hro"
                resval: "0"
            },
          ]
      }

       {
          name: B_48_MUX_SEL
          desc: '''
              Pad signal port multiplex selection for pad b_48. The programmed value defines which port
              is connected to the pad.
          '''
          swaccess: "rw"
          hwaccess: "hro"
          resval: 0
          fields: [
              {
                  bits: "1:0"
                  enum: [
                      { value: "0", name: "register", desc: "Connects the Pad to the internal configuration register."}
                      { value: "1", name: "port_eth_eth_rxck", desc: "Connect port eth_rxck from port group eth to this pad." }
                      { value: "2", name: "port_gpio_b_gpio48", desc: "Connect port gpio48 from port group gpio_b to this pad." }
                  ]
              }
          ]
      }

      {
          name: B_49_CFG
          desc: '''
            Pad signal configuration.
          '''
          swaccess: "rw"
          fields: [
            {
                bits: "0"
                name: chip2pad
                desc: '''
                     The signal that connects to the pads TX driver
                '''
                swaccess: "rw"
                hwaccess: "hro"
                resval: "0"
            },
            {
                bits: "2:1"
                name: drv
                desc: '''
                     Driving strength
                '''
                swaccess: "rw"
                hwaccess: "hro"
                resval: "0"
            },
            {
                bits: "3"
                name: oen
                desc: '''
                     Output enable signal, active low
                '''
                swaccess: "rw"
                hwaccess: "hro"
                resval: "1"
            },
            {
                bits: "4"
                name: puen
                desc: '''
                     Pull-Up enable signal, active low
                '''
                swaccess: "rw"
                hwaccess: "hro"
                resval: "1"
            },
            {
                bits: "5"
                name: slw
                desc: '''
                     
                '''
                swaccess: "rw"
                hwaccess: "hro"
                resval: "0"
            },
            {
                bits: "6"
                name: smt
                desc: '''
                     Schmit trigger enable
                '''
                swaccess: "rw"
                hwaccess: "hro"
                resval: "0"
            },
          ]
      }

       {
          name: B_49_MUX_SEL
          desc: '''
              Pad signal port multiplex selection for pad b_49. The programmed value defines which port
              is connected to the pad.
          '''
          swaccess: "rw"
          hwaccess: "hro"
          resval: 0
          fields: [
              {
                  bits: "1:0"
                  enum: [
                      { value: "0", name: "register", desc: "Connects the Pad to the internal configuration register."}
                      { value: "1", name: "port_eth_eth_rxctl", desc: "Connect port eth_rxctl from port group eth to this pad." }
                      { value: "2", name: "port_gpio_b_gpio49", desc: "Connect port gpio49 from port group gpio_b to this pad." }
                  ]
              }
          ]
      }

      {
          name: B_50_CFG
          desc: '''
            Pad signal configuration.
          '''
          swaccess: "rw"
          fields: [
            {
                bits: "0"
                name: chip2pad
                desc: '''
                     The signal that connects to the pads TX driver
                '''
                swaccess: "rw"
                hwaccess: "hro"
                resval: "0"
            },
            {
                bits: "2:1"
                name: drv
                desc: '''
                     Driving strength
                '''
                swaccess: "rw"
                hwaccess: "hro"
                resval: "0"
            },
            {
                bits: "3"
                name: oen
                desc: '''
                     Output enable signal, active low
                '''
                swaccess: "rw"
                hwaccess: "hro"
                resval: "1"
            },
            {
                bits: "4"
                name: puen
                desc: '''
                     Pull-Up enable signal, active low
                '''
                swaccess: "rw"
                hwaccess: "hro"
                resval: "1"
            },
            {
                bits: "5"
                name: slw
                desc: '''
                     
                '''
                swaccess: "rw"
                hwaccess: "hro"
                resval: "0"
            },
            {
                bits: "6"
                name: smt
                desc: '''
                     Schmit trigger enable
                '''
                swaccess: "rw"
                hwaccess: "hro"
                resval: "0"
            },
          ]
      }

       {
          name: B_50_MUX_SEL
          desc: '''
              Pad signal port multiplex selection for pad b_50. The programmed value defines which port
              is connected to the pad.
          '''
          swaccess: "rw"
          hwaccess: "hro"
          resval: 0
          fields: [
              {
                  bits: "1:0"
                  enum: [
                      { value: "0", name: "register", desc: "Connects the Pad to the internal configuration register."}
                      { value: "1", name: "port_eth_eth_rxd0", desc: "Connect port eth_rxd0 from port group eth to this pad." }
                      { value: "2", name: "port_gpio_b_gpio50", desc: "Connect port gpio50 from port group gpio_b to this pad." }
                  ]
              }
          ]
      }

      {
          name: B_51_CFG
          desc: '''
            Pad signal configuration.
          '''
          swaccess: "rw"
          fields: [
            {
                bits: "0"
                name: chip2pad
                desc: '''
                     The signal that connects to the pads TX driver
                '''
                swaccess: "rw"
                hwaccess: "hro"
                resval: "0"
            },
            {
                bits: "2:1"
                name: drv
                desc: '''
                     Driving strength
                '''
                swaccess: "rw"
                hwaccess: "hro"
                resval: "0"
            },
            {
                bits: "3"
                name: oen
                desc: '''
                     Output enable signal, active low
                '''
                swaccess: "rw"
                hwaccess: "hro"
                resval: "1"
            },
            {
                bits: "4"
                name: puen
                desc: '''
                     Pull-Up enable signal, active low
                '''
                swaccess: "rw"
                hwaccess: "hro"
                resval: "1"
            },
            {
                bits: "5"
                name: slw
                desc: '''
                     
                '''
                swaccess: "rw"
                hwaccess: "hro"
                resval: "0"
            },
            {
                bits: "6"
                name: smt
                desc: '''
                     Schmit trigger enable
                '''
                swaccess: "rw"
                hwaccess: "hro"
                resval: "0"
            },
          ]
      }

       {
          name: B_51_MUX_SEL
          desc: '''
              Pad signal port multiplex selection for pad b_51. The programmed value defines which port
              is connected to the pad.
          '''
          swaccess: "rw"
          hwaccess: "hro"
          resval: 0
          fields: [
              {
                  bits: "1:0"
                  enum: [
                      { value: "0", name: "register", desc: "Connects the Pad to the internal configuration register."}
                      { value: "1", name: "port_eth_eth_rxd1", desc: "Connect port eth_rxd1 from port group eth to this pad." }
                      { value: "2", name: "port_gpio_b_gpio51", desc: "Connect port gpio51 from port group gpio_b to this pad." }
                  ]
              }
          ]
      }

      {
          name: B_52_CFG
          desc: '''
            Pad signal configuration.
          '''
          swaccess: "rw"
          fields: [
            {
                bits: "0"
                name: chip2pad
                desc: '''
                     The signal that connects to the pads TX driver
                '''
                swaccess: "rw"
                hwaccess: "hro"
                resval: "0"
            },
            {
                bits: "2:1"
                name: drv
                desc: '''
                     Driving strength
                '''
                swaccess: "rw"
                hwaccess: "hro"
                resval: "0"
            },
            {
                bits: "3"
                name: oen
                desc: '''
                     Output enable signal, active low
                '''
                swaccess: "rw"
                hwaccess: "hro"
                resval: "1"
            },
            {
                bits: "4"
                name: puen
                desc: '''
                     Pull-Up enable signal, active low
                '''
                swaccess: "rw"
                hwaccess: "hro"
                resval: "1"
            },
            {
                bits: "5"
                name: slw
                desc: '''
                     
                '''
                swaccess: "rw"
                hwaccess: "hro"
                resval: "0"
            },
            {
                bits: "6"
                name: smt
                desc: '''
                     Schmit trigger enable
                '''
                swaccess: "rw"
                hwaccess: "hro"
                resval: "0"
            },
          ]
      }

       {
          name: B_52_MUX_SEL
          desc: '''
              Pad signal port multiplex selection for pad b_52. The programmed value defines which port
              is connected to the pad.
          '''
          swaccess: "rw"
          hwaccess: "hro"
          resval: 0
          fields: [
              {
                  bits: "1:0"
                  enum: [
                      { value: "0", name: "register", desc: "Connects the Pad to the internal configuration register."}
                      { value: "1", name: "port_eth_eth_rxd2", desc: "Connect port eth_rxd2 from port group eth to this pad." }
                      { value: "2", name: "port_gpio_b_gpio52", desc: "Connect port gpio52 from port group gpio_b to this pad." }
                  ]
              }
          ]
      }

      {
          name: B_53_CFG
          desc: '''
            Pad signal configuration.
          '''
          swaccess: "rw"
          fields: [
            {
                bits: "0"
                name: chip2pad
                desc: '''
                     The signal that connects to the pads TX driver
                '''
                swaccess: "rw"
                hwaccess: "hro"
                resval: "0"
            },
            {
                bits: "2:1"
                name: drv
                desc: '''
                     Driving strength
                '''
                swaccess: "rw"
                hwaccess: "hro"
                resval: "0"
            },
            {
                bits: "3"
                name: oen
                desc: '''
                     Output enable signal, active low
                '''
                swaccess: "rw"
                hwaccess: "hro"
                resval: "1"
            },
            {
                bits: "4"
                name: puen
                desc: '''
                     Pull-Up enable signal, active low
                '''
                swaccess: "rw"
                hwaccess: "hro"
                resval: "1"
            },
            {
                bits: "5"
                name: slw
                desc: '''
                     
                '''
                swaccess: "rw"
                hwaccess: "hro"
                resval: "0"
            },
            {
                bits: "6"
                name: smt
                desc: '''
                     Schmit trigger enable
                '''
                swaccess: "rw"
                hwaccess: "hro"
                resval: "0"
            },
          ]
      }

       {
          name: B_53_MUX_SEL
          desc: '''
              Pad signal port multiplex selection for pad b_53. The programmed value defines which port
              is connected to the pad.
          '''
          swaccess: "rw"
          hwaccess: "hro"
          resval: 0
          fields: [
              {
                  bits: "1:0"
                  enum: [
                      { value: "0", name: "register", desc: "Connects the Pad to the internal configuration register."}
                      { value: "1", name: "port_eth_eth_rxd3", desc: "Connect port eth_rxd3 from port group eth to this pad." }
                      { value: "2", name: "port_gpio_b_gpio53", desc: "Connect port gpio53 from port group gpio_b to this pad." }
                  ]
              }
          ]
      }

      {
          name: B_54_CFG
          desc: '''
            Pad signal configuration.
          '''
          swaccess: "rw"
          fields: [
            {
                bits: "0"
                name: chip2pad
                desc: '''
                     The signal that connects to the pads TX driver
                '''
                swaccess: "rw"
                hwaccess: "hro"
                resval: "0"
            },
            {
                bits: "2:1"
                name: drv
                desc: '''
                     Driving strength
                '''
                swaccess: "rw"
                hwaccess: "hro"
                resval: "0"
            },
            {
                bits: "3"
                name: oen
                desc: '''
                     Output enable signal, active low
                '''
                swaccess: "rw"
                hwaccess: "hro"
                resval: "1"
            },
            {
                bits: "4"
                name: puen
                desc: '''
                     Pull-Up enable signal, active low
                '''
                swaccess: "rw"
                hwaccess: "hro"
                resval: "1"
            },
            {
                bits: "5"
                name: slw
                desc: '''
                     
                '''
                swaccess: "rw"
                hwaccess: "hro"
                resval: "0"
            },
            {
                bits: "6"
                name: smt
                desc: '''
                     Schmit trigger enable
                '''
                swaccess: "rw"
                hwaccess: "hro"
                resval: "0"
            },
          ]
      }

       {
          name: B_54_MUX_SEL
          desc: '''
              Pad signal port multiplex selection for pad b_54. The programmed value defines which port
              is connected to the pad.
          '''
          swaccess: "rw"
          hwaccess: "hro"
          resval: 0
          fields: [
              {
                  bits: "1:0"
                  enum: [
                      { value: "0", name: "register", desc: "Connects the Pad to the internal configuration register."}
                      { value: "1", name: "port_eth_eth_txck", desc: "Connect port eth_txck from port group eth to this pad." }
                      { value: "2", name: "port_gpio_b_gpio54", desc: "Connect port gpio54 from port group gpio_b to this pad." }
                  ]
              }
          ]
      }

      {
          name: B_55_CFG
          desc: '''
            Pad signal configuration.
          '''
          swaccess: "rw"
          fields: [
            {
                bits: "0"
                name: chip2pad
                desc: '''
                     The signal that connects to the pads TX driver
                '''
                swaccess: "rw"
                hwaccess: "hro"
                resval: "0"
            },
            {
                bits: "2:1"
                name: drv
                desc: '''
                     Driving strength
                '''
                swaccess: "rw"
                hwaccess: "hro"
                resval: "0"
            },
            {
                bits: "3"
                name: oen
                desc: '''
                     Output enable signal, active low
                '''
                swaccess: "rw"
                hwaccess: "hro"
                resval: "1"
            },
            {
                bits: "4"
                name: puen
                desc: '''
                     Pull-Up enable signal, active low
                '''
                swaccess: "rw"
                hwaccess: "hro"
                resval: "1"
            },
            {
                bits: "5"
                name: slw
                desc: '''
                     
                '''
                swaccess: "rw"
                hwaccess: "hro"
                resval: "0"
            },
            {
                bits: "6"
                name: smt
                desc: '''
                     Schmit trigger enable
                '''
                swaccess: "rw"
                hwaccess: "hro"
                resval: "0"
            },
          ]
      }

       {
          name: B_55_MUX_SEL
          desc: '''
              Pad signal port multiplex selection for pad b_55. The programmed value defines which port
              is connected to the pad.
          '''
          swaccess: "rw"
          hwaccess: "hro"
          resval: 0
          fields: [
              {
                  bits: "1:0"
                  enum: [
                      { value: "0", name: "register", desc: "Connects the Pad to the internal configuration register."}
                      { value: "1", name: "port_eth_eth_txctl", desc: "Connect port eth_txctl from port group eth to this pad." }
                      { value: "2", name: "port_gpio_b_gpio55", desc: "Connect port gpio55 from port group gpio_b to this pad." }
                  ]
              }
          ]
      }

      {
          name: B_56_CFG
          desc: '''
            Pad signal configuration.
          '''
          swaccess: "rw"
          fields: [
            {
                bits: "0"
                name: chip2pad
                desc: '''
                     The signal that connects to the pads TX driver
                '''
                swaccess: "rw"
                hwaccess: "hro"
                resval: "0"
            },
            {
                bits: "2:1"
                name: drv
                desc: '''
                     Driving strength
                '''
                swaccess: "rw"
                hwaccess: "hro"
                resval: "0"
            },
            {
                bits: "3"
                name: oen
                desc: '''
                     Output enable signal, active low
                '''
                swaccess: "rw"
                hwaccess: "hro"
                resval: "1"
            },
            {
                bits: "4"
                name: puen
                desc: '''
                     Pull-Up enable signal, active low
                '''
                swaccess: "rw"
                hwaccess: "hro"
                resval: "1"
            },
            {
                bits: "5"
                name: slw
                desc: '''
                     
                '''
                swaccess: "rw"
                hwaccess: "hro"
                resval: "0"
            },
            {
                bits: "6"
                name: smt
                desc: '''
                     Schmit trigger enable
                '''
                swaccess: "rw"
                hwaccess: "hro"
                resval: "0"
            },
          ]
      }

       {
          name: B_56_MUX_SEL
          desc: '''
              Pad signal port multiplex selection for pad b_56. The programmed value defines which port
              is connected to the pad.
          '''
          swaccess: "rw"
          hwaccess: "hro"
          resval: 0
          fields: [
              {
                  bits: "1:0"
                  enum: [
                      { value: "0", name: "register", desc: "Connects the Pad to the internal configuration register."}
                      { value: "1", name: "port_eth_eth_txd0", desc: "Connect port eth_txd0 from port group eth to this pad." }
                      { value: "2", name: "port_gpio_b_gpio56", desc: "Connect port gpio56 from port group gpio_b to this pad." }
                  ]
              }
          ]
      }

      {
          name: B_57_CFG
          desc: '''
            Pad signal configuration.
          '''
          swaccess: "rw"
          fields: [
            {
                bits: "0"
                name: chip2pad
                desc: '''
                     The signal that connects to the pads TX driver
                '''
                swaccess: "rw"
                hwaccess: "hro"
                resval: "0"
            },
            {
                bits: "2:1"
                name: drv
                desc: '''
                     Driving strength
                '''
                swaccess: "rw"
                hwaccess: "hro"
                resval: "0"
            },
            {
                bits: "3"
                name: oen
                desc: '''
                     Output enable signal, active low
                '''
                swaccess: "rw"
                hwaccess: "hro"
                resval: "1"
            },
            {
                bits: "4"
                name: puen
                desc: '''
                     Pull-Up enable signal, active low
                '''
                swaccess: "rw"
                hwaccess: "hro"
                resval: "1"
            },
            {
                bits: "5"
                name: slw
                desc: '''
                     
                '''
                swaccess: "rw"
                hwaccess: "hro"
                resval: "0"
            },
            {
                bits: "6"
                name: smt
                desc: '''
                     Schmit trigger enable
                '''
                swaccess: "rw"
                hwaccess: "hro"
                resval: "0"
            },
          ]
      }

       {
          name: B_57_MUX_SEL
          desc: '''
              Pad signal port multiplex selection for pad b_57. The programmed value defines which port
              is connected to the pad.
          '''
          swaccess: "rw"
          hwaccess: "hro"
          resval: 0
          fields: [
              {
                  bits: "1:0"
                  enum: [
                      { value: "0", name: "register", desc: "Connects the Pad to the internal configuration register."}
                      { value: "1", name: "port_eth_eth_txd1", desc: "Connect port eth_txd1 from port group eth to this pad." }
                      { value: "2", name: "port_gpio_b_gpio57", desc: "Connect port gpio57 from port group gpio_b to this pad." }
                  ]
              }
          ]
      }

      {
          name: B_58_CFG
          desc: '''
            Pad signal configuration.
          '''
          swaccess: "rw"
          fields: [
            {
                bits: "0"
                name: chip2pad
                desc: '''
                     The signal that connects to the pads TX driver
                '''
                swaccess: "rw"
                hwaccess: "hro"
                resval: "0"
            },
            {
                bits: "2:1"
                name: drv
                desc: '''
                     Driving strength
                '''
                swaccess: "rw"
                hwaccess: "hro"
                resval: "0"
            },
            {
                bits: "3"
                name: oen
                desc: '''
                     Output enable signal, active low
                '''
                swaccess: "rw"
                hwaccess: "hro"
                resval: "1"
            },
            {
                bits: "4"
                name: puen
                desc: '''
                     Pull-Up enable signal, active low
                '''
                swaccess: "rw"
                hwaccess: "hro"
                resval: "1"
            },
            {
                bits: "5"
                name: slw
                desc: '''
                     
                '''
                swaccess: "rw"
                hwaccess: "hro"
                resval: "0"
            },
            {
                bits: "6"
                name: smt
                desc: '''
                     Schmit trigger enable
                '''
                swaccess: "rw"
                hwaccess: "hro"
                resval: "0"
            },
          ]
      }

       {
          name: B_58_MUX_SEL
          desc: '''
              Pad signal port multiplex selection for pad b_58. The programmed value defines which port
              is connected to the pad.
          '''
          swaccess: "rw"
          hwaccess: "hro"
          resval: 0
          fields: [
              {
                  bits: "1:0"
                  enum: [
                      { value: "0", name: "register", desc: "Connects the Pad to the internal configuration register."}
                      { value: "1", name: "port_eth_eth_txd2", desc: "Connect port eth_txd2 from port group eth to this pad." }
                      { value: "2", name: "port_gpio_b_gpio58", desc: "Connect port gpio58 from port group gpio_b to this pad." }
                  ]
              }
          ]
      }

      {
          name: B_59_CFG
          desc: '''
            Pad signal configuration.
          '''
          swaccess: "rw"
          fields: [
            {
                bits: "0"
                name: chip2pad
                desc: '''
                     The signal that connects to the pads TX driver
                '''
                swaccess: "rw"
                hwaccess: "hro"
                resval: "0"
            },
            {
                bits: "2:1"
                name: drv
                desc: '''
                     Driving strength
                '''
                swaccess: "rw"
                hwaccess: "hro"
                resval: "0"
            },
            {
                bits: "3"
                name: oen
                desc: '''
                     Output enable signal, active low
                '''
                swaccess: "rw"
                hwaccess: "hro"
                resval: "1"
            },
            {
                bits: "4"
                name: puen
                desc: '''
                     Pull-Up enable signal, active low
                '''
                swaccess: "rw"
                hwaccess: "hro"
                resval: "1"
            },
            {
                bits: "5"
                name: slw
                desc: '''
                     
                '''
                swaccess: "rw"
                hwaccess: "hro"
                resval: "0"
            },
            {
                bits: "6"
                name: smt
                desc: '''
                     Schmit trigger enable
                '''
                swaccess: "rw"
                hwaccess: "hro"
                resval: "0"
            },
          ]
      }

       {
          name: B_59_MUX_SEL
          desc: '''
              Pad signal port multiplex selection for pad b_59. The programmed value defines which port
              is connected to the pad.
          '''
          swaccess: "rw"
          hwaccess: "hro"
          resval: 0
          fields: [
              {
                  bits: "1:0"
                  enum: [
                      { value: "0", name: "register", desc: "Connects the Pad to the internal configuration register."}
                      { value: "1", name: "port_eth_eth_txd3", desc: "Connect port eth_txd3 from port group eth to this pad." }
                      { value: "2", name: "port_gpio_b_gpio59", desc: "Connect port gpio59 from port group gpio_b to this pad." }
                  ]
              }
          ]
      }

      {
          name: B_60_CFG
          desc: '''
            Pad signal configuration.
          '''
          swaccess: "rw"
          fields: [
            {
                bits: "0"
                name: chip2pad
                desc: '''
                     The signal that connects to the pads TX driver
                '''
                swaccess: "rw"
                hwaccess: "hro"
                resval: "0"
            },
            {
                bits: "2:1"
                name: drv
                desc: '''
                     Driving strength
                '''
                swaccess: "rw"
                hwaccess: "hro"
                resval: "0"
            },
            {
                bits: "3"
                name: oen
                desc: '''
                     Output enable signal, active low
                '''
                swaccess: "rw"
                hwaccess: "hro"
                resval: "1"
            },
            {
                bits: "4"
                name: puen
                desc: '''
                     Pull-Up enable signal, active low
                '''
                swaccess: "rw"
                hwaccess: "hro"
                resval: "1"
            },
            {
                bits: "5"
                name: slw
                desc: '''
                     
                '''
                swaccess: "rw"
                hwaccess: "hro"
                resval: "0"
            },
            {
                bits: "6"
                name: smt
                desc: '''
                     Schmit trigger enable
                '''
                swaccess: "rw"
                hwaccess: "hro"
                resval: "0"
            },
          ]
      }

       {
          name: B_60_MUX_SEL
          desc: '''
              Pad signal port multiplex selection for pad b_60. The programmed value defines which port
              is connected to the pad.
          '''
          swaccess: "rw"
          hwaccess: "hro"
          resval: 0
          fields: [
              {
                  bits: "1:0"
                  enum: [
                      { value: "0", name: "register", desc: "Connects the Pad to the internal configuration register."}
                      { value: "1", name: "port_eth_eth_mdio", desc: "Connect port eth_mdio from port group eth to this pad." }
                      { value: "2", name: "port_gpio_b_gpio60", desc: "Connect port gpio60 from port group gpio_b to this pad." }
                  ]
              }
          ]
      }

      {
          name: B_61_CFG
          desc: '''
            Pad signal configuration.
          '''
          swaccess: "rw"
          fields: [
            {
                bits: "0"
                name: chip2pad
                desc: '''
                     The signal that connects to the pads TX driver
                '''
                swaccess: "rw"
                hwaccess: "hro"
                resval: "0"
            },
            {
                bits: "2:1"
                name: drv
                desc: '''
                     Driving strength
                '''
                swaccess: "rw"
                hwaccess: "hro"
                resval: "0"
            },
            {
                bits: "3"
                name: oen
                desc: '''
                     Output enable signal, active low
                '''
                swaccess: "rw"
                hwaccess: "hro"
                resval: "1"
            },
            {
                bits: "4"
                name: puen
                desc: '''
                     Pull-Up enable signal, active low
                '''
                swaccess: "rw"
                hwaccess: "hro"
                resval: "1"
            },
            {
                bits: "5"
                name: slw
                desc: '''
                     
                '''
                swaccess: "rw"
                hwaccess: "hro"
                resval: "0"
            },
            {
                bits: "6"
                name: smt
                desc: '''
                     Schmit trigger enable
                '''
                swaccess: "rw"
                hwaccess: "hro"
                resval: "0"
            },
          ]
      }

       {
          name: B_61_MUX_SEL
          desc: '''
              Pad signal port multiplex selection for pad b_61. The programmed value defines which port
              is connected to the pad.
          '''
          swaccess: "rw"
          hwaccess: "hro"
          resval: 0
          fields: [
              {
                  bits: "1:0"
                  enum: [
                      { value: "0", name: "register", desc: "Connects the Pad to the internal configuration register."}
                      { value: "1", name: "port_eth_eth_mdc", desc: "Connect port eth_mdc from port group eth to this pad." }
                      { value: "2", name: "port_gpio_b_gpio61", desc: "Connect port gpio61 from port group gpio_b to this pad." }
                  ]
              }
          ]
      }

      {
          name: B_62_CFG
          desc: '''
            Pad signal configuration.
          '''
          swaccess: "rw"
          fields: [
            {
                bits: "0"
                name: chip2pad
                desc: '''
                     The signal that connects to the pads TX driver
                '''
                swaccess: "rw"
                hwaccess: "hro"
                resval: "0"
            },
            {
                bits: "2:1"
                name: drv
                desc: '''
                     Driving strength
                '''
                swaccess: "rw"
                hwaccess: "hro"
                resval: "0"
            },
            {
                bits: "3"
                name: oen
                desc: '''
                     Output enable signal, active low
                '''
                swaccess: "rw"
                hwaccess: "hro"
                resval: "1"
            },
            {
                bits: "4"
                name: puen
                desc: '''
                     Pull-Up enable signal, active low
                '''
                swaccess: "rw"
                hwaccess: "hro"
                resval: "1"
            },
            {
                bits: "5"
                name: slw
                desc: '''
                     
                '''
                swaccess: "rw"
                hwaccess: "hro"
                resval: "0"
            },
            {
                bits: "6"
                name: smt
                desc: '''
                     Schmit trigger enable
                '''
                swaccess: "rw"
                hwaccess: "hro"
                resval: "0"
            },
          ]
      }

       {
          name: B_62_MUX_SEL
          desc: '''
              Pad signal port multiplex selection for pad b_62. The programmed value defines which port
              is connected to the pad.
          '''
          swaccess: "rw"
          hwaccess: "hro"
          resval: 0
          fields: [
              {
                  bits: "2:0"
                  enum: [
                      { value: "0", name: "register", desc: "Connects the Pad to the internal configuration register."}
                      { value: "1", name: "port_fll_cluster_clk_cluster", desc: "Connect port clk_cluster from port group fll_cluster to this pad." }
                      { value: "2", name: "port_fll_cva6_clk_cva6", desc: "Connect port clk_cva6 from port group fll_cva6 to this pad." }
                      { value: "3", name: "port_fll_per_clk_peripheral", desc: "Connect port clk_peripheral from port group fll_per to this pad." }
                      { value: "4", name: "port_fll_soc_clk_soc", desc: "Connect port clk_soc from port group fll_soc to this pad." }
                      { value: "5", name: "port_gpio_b_gpio62", desc: "Connect port gpio62 from port group gpio_b to this pad." }
                  ]
              }
          ]
      }

      {
          name: OT_QSPI_00_CFG
          desc: '''
            Pad signal configuration.
          '''
          swaccess: "rw"
          fields: [
            {
                bits: "0"
                name: chip2pad
                desc: '''
                     The signal that connects to the pads TX driver
                '''
                swaccess: "rw"
                hwaccess: "hro"
                resval: "0"
            },
            {
                bits: "2:1"
                name: drv
                desc: '''
                     Driving strength
                '''
                swaccess: "rw"
                hwaccess: "hro"
                resval: "0"
            },
            {
                bits: "3"
                name: oen
                desc: '''
                     Output enable signal, active low
                '''
                swaccess: "rw"
                hwaccess: "hro"
                resval: "1"
            },
            {
                bits: "4"
                name: puen
                desc: '''
                     Pull-Up enable signal, active low
                '''
                swaccess: "rw"
                hwaccess: "hro"
                resval: "1"
            },
            {
                bits: "5"
                name: slw
                desc: '''
                     
                '''
                swaccess: "rw"
                hwaccess: "hro"
                resval: "0"
            },
            {
                bits: "6"
                name: smt
                desc: '''
                     Schmit trigger enable
                '''
                swaccess: "rw"
                hwaccess: "hro"
                resval: "0"
            },
          ]
      }

       {
          name: OT_QSPI_00_MUX_SEL
          desc: '''
              Pad signal port multiplex selection for pad ot_qspi_00. The programmed value defines which port
              is connected to the pad.
          '''
          swaccess: "rw"
          hwaccess: "hro"
          resval: 0
          fields: [
              {
                  bits: "0:0"
                  enum: [
                      { value: "0", name: "register", desc: "Connects the Pad to the internal configuration register."}
                      { value: "1", name: "port_qspi_ot_qspi_sck", desc: "Connect port qspi_sck from port group qspi_ot to this pad." }
                  ]
              }
          ]
      }

      {
          name: OT_QSPI_01_CFG
          desc: '''
            Pad signal configuration.
          '''
          swaccess: "rw"
          fields: [
            {
                bits: "0"
                name: chip2pad
                desc: '''
                     The signal that connects to the pads TX driver
                '''
                swaccess: "rw"
                hwaccess: "hro"
                resval: "0"
            },
            {
                bits: "2:1"
                name: drv
                desc: '''
                     Driving strength
                '''
                swaccess: "rw"
                hwaccess: "hro"
                resval: "0"
            },
            {
                bits: "3"
                name: oen
                desc: '''
                     Output enable signal, active low
                '''
                swaccess: "rw"
                hwaccess: "hro"
                resval: "1"
            },
            {
                bits: "4"
                name: puen
                desc: '''
                     Pull-Up enable signal, active low
                '''
                swaccess: "rw"
                hwaccess: "hro"
                resval: "1"
            },
            {
                bits: "5"
                name: slw
                desc: '''
                     
                '''
                swaccess: "rw"
                hwaccess: "hro"
                resval: "0"
            },
            {
                bits: "6"
                name: smt
                desc: '''
                     Schmit trigger enable
                '''
                swaccess: "rw"
                hwaccess: "hro"
                resval: "0"
            },
          ]
      }

       {
          name: OT_QSPI_01_MUX_SEL
          desc: '''
              Pad signal port multiplex selection for pad ot_qspi_01. The programmed value defines which port
              is connected to the pad.
          '''
          swaccess: "rw"
          hwaccess: "hro"
          resval: 0
          fields: [
              {
                  bits: "0:0"
                  enum: [
                      { value: "0", name: "register", desc: "Connects the Pad to the internal configuration register."}
                      { value: "1", name: "port_qspi_ot_qspi_csn", desc: "Connect port qspi_csn from port group qspi_ot to this pad." }
                  ]
              }
          ]
      }

      {
          name: OT_QSPI_02_CFG
          desc: '''
            Pad signal configuration.
          '''
          swaccess: "rw"
          fields: [
            {
                bits: "0"
                name: chip2pad
                desc: '''
                     The signal that connects to the pads TX driver
                '''
                swaccess: "rw"
                hwaccess: "hro"
                resval: "0"
            },
            {
                bits: "2:1"
                name: drv
                desc: '''
                     Driving strength
                '''
                swaccess: "rw"
                hwaccess: "hro"
                resval: "0"
            },
            {
                bits: "3"
                name: oen
                desc: '''
                     Output enable signal, active low
                '''
                swaccess: "rw"
                hwaccess: "hro"
                resval: "1"
            },
            {
                bits: "4"
                name: puen
                desc: '''
                     Pull-Up enable signal, active low
                '''
                swaccess: "rw"
                hwaccess: "hro"
                resval: "1"
            },
            {
                bits: "5"
                name: slw
                desc: '''
                     
                '''
                swaccess: "rw"
                hwaccess: "hro"
                resval: "0"
            },
            {
                bits: "6"
                name: smt
                desc: '''
                     Schmit trigger enable
                '''
                swaccess: "rw"
                hwaccess: "hro"
                resval: "0"
            },
          ]
      }

       {
          name: OT_QSPI_02_MUX_SEL
          desc: '''
              Pad signal port multiplex selection for pad ot_qspi_02. The programmed value defines which port
              is connected to the pad.
          '''
          swaccess: "rw"
          hwaccess: "hro"
          resval: 0
          fields: [
              {
                  bits: "0:0"
                  enum: [
                      { value: "0", name: "register", desc: "Connects the Pad to the internal configuration register."}
                      { value: "1", name: "port_qspi_ot_qspi_sd0", desc: "Connect port qspi_sd0 from port group qspi_ot to this pad." }
                  ]
              }
          ]
      }

      {
          name: OT_QSPI_03_CFG
          desc: '''
            Pad signal configuration.
          '''
          swaccess: "rw"
          fields: [
            {
                bits: "0"
                name: chip2pad
                desc: '''
                     The signal that connects to the pads TX driver
                '''
                swaccess: "rw"
                hwaccess: "hro"
                resval: "0"
            },
            {
                bits: "2:1"
                name: drv
                desc: '''
                     Driving strength
                '''
                swaccess: "rw"
                hwaccess: "hro"
                resval: "0"
            },
            {
                bits: "3"
                name: oen
                desc: '''
                     Output enable signal, active low
                '''
                swaccess: "rw"
                hwaccess: "hro"
                resval: "1"
            },
            {
                bits: "4"
                name: puen
                desc: '''
                     Pull-Up enable signal, active low
                '''
                swaccess: "rw"
                hwaccess: "hro"
                resval: "1"
            },
            {
                bits: "5"
                name: slw
                desc: '''
                     
                '''
                swaccess: "rw"
                hwaccess: "hro"
                resval: "0"
            },
            {
                bits: "6"
                name: smt
                desc: '''
                     Schmit trigger enable
                '''
                swaccess: "rw"
                hwaccess: "hro"
                resval: "0"
            },
          ]
      }

       {
          name: OT_QSPI_03_MUX_SEL
          desc: '''
              Pad signal port multiplex selection for pad ot_qspi_03. The programmed value defines which port
              is connected to the pad.
          '''
          swaccess: "rw"
          hwaccess: "hro"
          resval: 0
          fields: [
              {
                  bits: "0:0"
                  enum: [
                      { value: "0", name: "register", desc: "Connects the Pad to the internal configuration register."}
                      { value: "1", name: "port_qspi_ot_qspi_sd1", desc: "Connect port qspi_sd1 from port group qspi_ot to this pad." }
                  ]
              }
          ]
      }

      {
          name: OT_QSPI_04_CFG
          desc: '''
            Pad signal configuration.
          '''
          swaccess: "rw"
          fields: [
            {
                bits: "0"
                name: chip2pad
                desc: '''
                     The signal that connects to the pads TX driver
                '''
                swaccess: "rw"
                hwaccess: "hro"
                resval: "0"
            },
            {
                bits: "2:1"
                name: drv
                desc: '''
                     Driving strength
                '''
                swaccess: "rw"
                hwaccess: "hro"
                resval: "0"
            },
            {
                bits: "3"
                name: oen
                desc: '''
                     Output enable signal, active low
                '''
                swaccess: "rw"
                hwaccess: "hro"
                resval: "1"
            },
            {
                bits: "4"
                name: puen
                desc: '''
                     Pull-Up enable signal, active low
                '''
                swaccess: "rw"
                hwaccess: "hro"
                resval: "1"
            },
            {
                bits: "5"
                name: slw
                desc: '''
                     
                '''
                swaccess: "rw"
                hwaccess: "hro"
                resval: "0"
            },
            {
                bits: "6"
                name: smt
                desc: '''
                     Schmit trigger enable
                '''
                swaccess: "rw"
                hwaccess: "hro"
                resval: "0"
            },
          ]
      }

       {
          name: OT_QSPI_04_MUX_SEL
          desc: '''
              Pad signal port multiplex selection for pad ot_qspi_04. The programmed value defines which port
              is connected to the pad.
          '''
          swaccess: "rw"
          hwaccess: "hro"
          resval: 0
          fields: [
              {
                  bits: "0:0"
                  enum: [
                      { value: "0", name: "register", desc: "Connects the Pad to the internal configuration register."}
                      { value: "1", name: "port_qspi_ot_qspi_sd2", desc: "Connect port qspi_sd2 from port group qspi_ot to this pad." }
                  ]
              }
          ]
      }

      {
          name: OT_QSPI_05_CFG
          desc: '''
            Pad signal configuration.
          '''
          swaccess: "rw"
          fields: [
            {
                bits: "0"
                name: chip2pad
                desc: '''
                     The signal that connects to the pads TX driver
                '''
                swaccess: "rw"
                hwaccess: "hro"
                resval: "0"
            },
            {
                bits: "2:1"
                name: drv
                desc: '''
                     Driving strength
                '''
                swaccess: "rw"
                hwaccess: "hro"
                resval: "0"
            },
            {
                bits: "3"
                name: oen
                desc: '''
                     Output enable signal, active low
                '''
                swaccess: "rw"
                hwaccess: "hro"
                resval: "1"
            },
            {
                bits: "4"
                name: puen
                desc: '''
                     Pull-Up enable signal, active low
                '''
                swaccess: "rw"
                hwaccess: "hro"
                resval: "1"
            },
            {
                bits: "5"
                name: slw
                desc: '''
                     
                '''
                swaccess: "rw"
                hwaccess: "hro"
                resval: "0"
            },
            {
                bits: "6"
                name: smt
                desc: '''
                     Schmit trigger enable
                '''
                swaccess: "rw"
                hwaccess: "hro"
                resval: "0"
            },
          ]
      }

       {
          name: OT_QSPI_05_MUX_SEL
          desc: '''
              Pad signal port multiplex selection for pad ot_qspi_05. The programmed value defines which port
              is connected to the pad.
          '''
          swaccess: "rw"
          hwaccess: "hro"
          resval: 0
          fields: [
              {
                  bits: "0:0"
                  enum: [
                      { value: "0", name: "register", desc: "Connects the Pad to the internal configuration register."}
                      { value: "1", name: "port_qspi_ot_qspi_sd3", desc: "Connect port qspi_sd3 from port group qspi_ot to this pad." }
                  ]
              }
          ]
      }

      {
          name: LINUX_QSPI_00_CFG
          desc: '''
            Pad signal configuration.
          '''
          swaccess: "rw"
          fields: [
            {
                bits: "0"
                name: chip2pad
                desc: '''
                     The signal that connects to the pads TX driver
                '''
                swaccess: "rw"
                hwaccess: "hro"
                resval: "0"
            },
            {
                bits: "2:1"
                name: drv
                desc: '''
                     Driving strength
                '''
                swaccess: "rw"
                hwaccess: "hro"
                resval: "0"
            },
            {
                bits: "3"
                name: oen
                desc: '''
                     Output enable signal, active low
                '''
                swaccess: "rw"
                hwaccess: "hro"
                resval: "1"
            },
            {
                bits: "4"
                name: puen
                desc: '''
                     Pull-Up enable signal, active low
                '''
                swaccess: "rw"
                hwaccess: "hro"
                resval: "1"
            },
            {
                bits: "5"
                name: slw
                desc: '''
                     
                '''
                swaccess: "rw"
                hwaccess: "hro"
                resval: "0"
            },
            {
                bits: "6"
                name: smt
                desc: '''
                     Schmit trigger enable
                '''
                swaccess: "rw"
                hwaccess: "hro"
                resval: "0"
            },
          ]
      }

       {
          name: LINUX_QSPI_00_MUX_SEL
          desc: '''
              Pad signal port multiplex selection for pad linux_qspi_00. The programmed value defines which port
              is connected to the pad.
          '''
          swaccess: "rw"
          hwaccess: "hro"
          resval: 0
          fields: [
              {
                  bits: "0:0"
                  enum: [
                      { value: "0", name: "register", desc: "Connects the Pad to the internal configuration register."}
                      { value: "1", name: "port_qspi_linux_qspi_sck", desc: "Connect port qspi_sck from port group qspi_linux to this pad." }
                  ]
              }
          ]
      }

      {
          name: LINUX_QSPI_01_CFG
          desc: '''
            Pad signal configuration.
          '''
          swaccess: "rw"
          fields: [
            {
                bits: "0"
                name: chip2pad
                desc: '''
                     The signal that connects to the pads TX driver
                '''
                swaccess: "rw"
                hwaccess: "hro"
                resval: "0"
            },
            {
                bits: "2:1"
                name: drv
                desc: '''
                     Driving strength
                '''
                swaccess: "rw"
                hwaccess: "hro"
                resval: "0"
            },
            {
                bits: "3"
                name: oen
                desc: '''
                     Output enable signal, active low
                '''
                swaccess: "rw"
                hwaccess: "hro"
                resval: "1"
            },
            {
                bits: "4"
                name: puen
                desc: '''
                     Pull-Up enable signal, active low
                '''
                swaccess: "rw"
                hwaccess: "hro"
                resval: "1"
            },
            {
                bits: "5"
                name: slw
                desc: '''
                     
                '''
                swaccess: "rw"
                hwaccess: "hro"
                resval: "0"
            },
            {
                bits: "6"
                name: smt
                desc: '''
                     Schmit trigger enable
                '''
                swaccess: "rw"
                hwaccess: "hro"
                resval: "0"
            },
          ]
      }

       {
          name: LINUX_QSPI_01_MUX_SEL
          desc: '''
              Pad signal port multiplex selection for pad linux_qspi_01. The programmed value defines which port
              is connected to the pad.
          '''
          swaccess: "rw"
          hwaccess: "hro"
          resval: 0
          fields: [
              {
                  bits: "0:0"
                  enum: [
                      { value: "0", name: "register", desc: "Connects the Pad to the internal configuration register."}
                      { value: "1", name: "port_qspi_linux_qspi_csn", desc: "Connect port qspi_csn from port group qspi_linux to this pad." }
                  ]
              }
          ]
      }

      {
          name: LINUX_QSPI_02_CFG
          desc: '''
            Pad signal configuration.
          '''
          swaccess: "rw"
          fields: [
            {
                bits: "0"
                name: chip2pad
                desc: '''
                     The signal that connects to the pads TX driver
                '''
                swaccess: "rw"
                hwaccess: "hro"
                resval: "0"
            },
            {
                bits: "2:1"
                name: drv
                desc: '''
                     Driving strength
                '''
                swaccess: "rw"
                hwaccess: "hro"
                resval: "0"
            },
            {
                bits: "3"
                name: oen
                desc: '''
                     Output enable signal, active low
                '''
                swaccess: "rw"
                hwaccess: "hro"
                resval: "1"
            },
            {
                bits: "4"
                name: puen
                desc: '''
                     Pull-Up enable signal, active low
                '''
                swaccess: "rw"
                hwaccess: "hro"
                resval: "1"
            },
            {
                bits: "5"
                name: slw
                desc: '''
                     
                '''
                swaccess: "rw"
                hwaccess: "hro"
                resval: "0"
            },
            {
                bits: "6"
                name: smt
                desc: '''
                     Schmit trigger enable
                '''
                swaccess: "rw"
                hwaccess: "hro"
                resval: "0"
            },
          ]
      }

       {
          name: LINUX_QSPI_02_MUX_SEL
          desc: '''
              Pad signal port multiplex selection for pad linux_qspi_02. The programmed value defines which port
              is connected to the pad.
          '''
          swaccess: "rw"
          hwaccess: "hro"
          resval: 0
          fields: [
              {
                  bits: "0:0"
                  enum: [
                      { value: "0", name: "register", desc: "Connects the Pad to the internal configuration register."}
                      { value: "1", name: "port_qspi_linux_qspi_sd0", desc: "Connect port qspi_sd0 from port group qspi_linux to this pad." }
                  ]
              }
          ]
      }

      {
          name: LINUX_QSPI_03_CFG
          desc: '''
            Pad signal configuration.
          '''
          swaccess: "rw"
          fields: [
            {
                bits: "0"
                name: chip2pad
                desc: '''
                     The signal that connects to the pads TX driver
                '''
                swaccess: "rw"
                hwaccess: "hro"
                resval: "0"
            },
            {
                bits: "2:1"
                name: drv
                desc: '''
                     Driving strength
                '''
                swaccess: "rw"
                hwaccess: "hro"
                resval: "0"
            },
            {
                bits: "3"
                name: oen
                desc: '''
                     Output enable signal, active low
                '''
                swaccess: "rw"
                hwaccess: "hro"
                resval: "1"
            },
            {
                bits: "4"
                name: puen
                desc: '''
                     Pull-Up enable signal, active low
                '''
                swaccess: "rw"
                hwaccess: "hro"
                resval: "1"
            },
            {
                bits: "5"
                name: slw
                desc: '''
                     
                '''
                swaccess: "rw"
                hwaccess: "hro"
                resval: "0"
            },
            {
                bits: "6"
                name: smt
                desc: '''
                     Schmit trigger enable
                '''
                swaccess: "rw"
                hwaccess: "hro"
                resval: "0"
            },
          ]
      }

       {
          name: LINUX_QSPI_03_MUX_SEL
          desc: '''
              Pad signal port multiplex selection for pad linux_qspi_03. The programmed value defines which port
              is connected to the pad.
          '''
          swaccess: "rw"
          hwaccess: "hro"
          resval: 0
          fields: [
              {
                  bits: "0:0"
                  enum: [
                      { value: "0", name: "register", desc: "Connects the Pad to the internal configuration register."}
                      { value: "1", name: "port_qspi_linux_qspi_sd1", desc: "Connect port qspi_sd1 from port group qspi_linux to this pad." }
                  ]
              }
          ]
      }

      {
          name: LINUX_QSPI_04_CFG
          desc: '''
            Pad signal configuration.
          '''
          swaccess: "rw"
          fields: [
            {
                bits: "0"
                name: chip2pad
                desc: '''
                     The signal that connects to the pads TX driver
                '''
                swaccess: "rw"
                hwaccess: "hro"
                resval: "0"
            },
            {
                bits: "2:1"
                name: drv
                desc: '''
                     Driving strength
                '''
                swaccess: "rw"
                hwaccess: "hro"
                resval: "0"
            },
            {
                bits: "3"
                name: oen
                desc: '''
                     Output enable signal, active low
                '''
                swaccess: "rw"
                hwaccess: "hro"
                resval: "1"
            },
            {
                bits: "4"
                name: puen
                desc: '''
                     Pull-Up enable signal, active low
                '''
                swaccess: "rw"
                hwaccess: "hro"
                resval: "1"
            },
            {
                bits: "5"
                name: slw
                desc: '''
                     
                '''
                swaccess: "rw"
                hwaccess: "hro"
                resval: "0"
            },
            {
                bits: "6"
                name: smt
                desc: '''
                     Schmit trigger enable
                '''
                swaccess: "rw"
                hwaccess: "hro"
                resval: "0"
            },
          ]
      }

       {
          name: LINUX_QSPI_04_MUX_SEL
          desc: '''
              Pad signal port multiplex selection for pad linux_qspi_04. The programmed value defines which port
              is connected to the pad.
          '''
          swaccess: "rw"
          hwaccess: "hro"
          resval: 0
          fields: [
              {
                  bits: "0:0"
                  enum: [
                      { value: "0", name: "register", desc: "Connects the Pad to the internal configuration register."}
                      { value: "1", name: "port_qspi_linux_qspi_sd2", desc: "Connect port qspi_sd2 from port group qspi_linux to this pad." }
                  ]
              }
          ]
      }

      {
          name: LINUX_QSPI_05_CFG
          desc: '''
            Pad signal configuration.
          '''
          swaccess: "rw"
          fields: [
            {
                bits: "0"
                name: chip2pad
                desc: '''
                     The signal that connects to the pads TX driver
                '''
                swaccess: "rw"
                hwaccess: "hro"
                resval: "0"
            },
            {
                bits: "2:1"
                name: drv
                desc: '''
                     Driving strength
                '''
                swaccess: "rw"
                hwaccess: "hro"
                resval: "0"
            },
            {
                bits: "3"
                name: oen
                desc: '''
                     Output enable signal, active low
                '''
                swaccess: "rw"
                hwaccess: "hro"
                resval: "1"
            },
            {
                bits: "4"
                name: puen
                desc: '''
                     Pull-Up enable signal, active low
                '''
                swaccess: "rw"
                hwaccess: "hro"
                resval: "1"
            },
            {
                bits: "5"
                name: slw
                desc: '''
                     
                '''
                swaccess: "rw"
                hwaccess: "hro"
                resval: "0"
            },
            {
                bits: "6"
                name: smt
                desc: '''
                     Schmit trigger enable
                '''
                swaccess: "rw"
                hwaccess: "hro"
                resval: "0"
            },
          ]
      }

       {
          name: LINUX_QSPI_05_MUX_SEL
          desc: '''
              Pad signal port multiplex selection for pad linux_qspi_05. The programmed value defines which port
              is connected to the pad.
          '''
          swaccess: "rw"
          hwaccess: "hro"
          resval: 0
          fields: [
              {
                  bits: "0:0"
                  enum: [
                      { value: "0", name: "register", desc: "Connects the Pad to the internal configuration register."}
                      { value: "1", name: "port_qspi_linux_qspi_sd3", desc: "Connect port qspi_sd3 from port group qspi_linux to this pad." }
                  ]
              }
          ]
      }

      {
          name: OT_GPIO_00_CFG
          desc: '''
            Pad signal configuration.
          '''
          swaccess: "rw"
          fields: [
            {
                bits: "0"
                name: chip2pad
                desc: '''
                     The signal that connects to the pads TX driver
                '''
                swaccess: "rw"
                hwaccess: "hro"
                resval: "0"
            },
            {
                bits: "2:1"
                name: drv
                desc: '''
                     Driving strength
                '''
                swaccess: "rw"
                hwaccess: "hro"
                resval: "0"
            },
            {
                bits: "3"
                name: oen
                desc: '''
                     Output enable signal, active low
                '''
                swaccess: "rw"
                hwaccess: "hro"
                resval: "1"
            },
            {
                bits: "4"
                name: puen
                desc: '''
                     Pull-Up enable signal, active low
                '''
                swaccess: "rw"
                hwaccess: "hro"
                resval: "1"
            },
            {
                bits: "5"
                name: slw
                desc: '''
                     
                '''
                swaccess: "rw"
                hwaccess: "hro"
                resval: "0"
            },
            {
                bits: "6"
                name: smt
                desc: '''
                     Schmit trigger enable
                '''
                swaccess: "rw"
                hwaccess: "hro"
                resval: "0"
            },
          ]
      }

       {
          name: OT_GPIO_00_MUX_SEL
          desc: '''
              Pad signal port multiplex selection for pad ot_gpio_00. The programmed value defines which port
              is connected to the pad.
          '''
          swaccess: "rw"
          hwaccess: "hro"
          resval: 0
          fields: [
              {
                  bits: "0:0"
                  enum: [
                      { value: "0", name: "register", desc: "Connects the Pad to the internal configuration register."}
                      { value: "1", name: "port_ot_gpio_op_gpio0", desc: "Connect port op_gpio0 from port group ot_gpio to this pad." }
                  ]
              }
          ]
      }

      {
          name: OT_GPIO_01_CFG
          desc: '''
            Pad signal configuration.
          '''
          swaccess: "rw"
          fields: [
            {
                bits: "0"
                name: chip2pad
                desc: '''
                     The signal that connects to the pads TX driver
                '''
                swaccess: "rw"
                hwaccess: "hro"
                resval: "0"
            },
            {
                bits: "2:1"
                name: drv
                desc: '''
                     Driving strength
                '''
                swaccess: "rw"
                hwaccess: "hro"
                resval: "0"
            },
            {
                bits: "3"
                name: oen
                desc: '''
                     Output enable signal, active low
                '''
                swaccess: "rw"
                hwaccess: "hro"
                resval: "1"
            },
            {
                bits: "4"
                name: puen
                desc: '''
                     Pull-Up enable signal, active low
                '''
                swaccess: "rw"
                hwaccess: "hro"
                resval: "1"
            },
            {
                bits: "5"
                name: slw
                desc: '''
                     
                '''
                swaccess: "rw"
                hwaccess: "hro"
                resval: "0"
            },
            {
                bits: "6"
                name: smt
                desc: '''
                     Schmit trigger enable
                '''
                swaccess: "rw"
                hwaccess: "hro"
                resval: "0"
            },
          ]
      }

       {
          name: OT_GPIO_01_MUX_SEL
          desc: '''
              Pad signal port multiplex selection for pad ot_gpio_01. The programmed value defines which port
              is connected to the pad.
          '''
          swaccess: "rw"
          hwaccess: "hro"
          resval: 0
          fields: [
              {
                  bits: "0:0"
                  enum: [
                      { value: "0", name: "register", desc: "Connects the Pad to the internal configuration register."}
                      { value: "1", name: "port_ot_gpio_op_gpio1", desc: "Connect port op_gpio1 from port group ot_gpio to this pad." }
                  ]
              }
          ]
      }

    ]
}
